;; 用 SKILL 建一个分压器 —— 和 Virtuoso 里写的是同一套 db* 调用
procedure( mkDivider (lib cell)
  let( (cv r1 r2 ts)
    cv = dbOpenCellViewByType(lib cell "schematic" "schematic" "w")
    dbCreateTerm(cv "in"  "input")
    dbCreateTerm(cv "out" "output")
    dbCreateTerm(cv "gnd" "inputOutput")
    r1 = dbCreateInst(cv "vlightLib res" "R1" list(0 0)   "R0")
    r2 = dbCreateInst(cv "vlightLib res" "R2" list(0 -40) "R0")
    ts = r1~>instTerms
    printf("R1 的端子: %L\n" mapcar( lambda( (tm) tm~>name ) ts ))
    dbReplaceProp(r1 "r" "1k")
    dbReplaceProp(r2 "r" "2k")
    dbCreateConnByName( car(ts)  "in")
    dbCreateConnByName( cadr(ts) "out")
    dbCreateConnByName( car(r2~>instTerms)  "out")
    dbCreateConnByName( cadr(r2~>instTerms) "gnd")
    schCheck(cv)
    dbSave(cv)
    dbClose(cv)
    sprintf(nil "%s/%s 建好，%d 个实例" lib cell length(cv~>instances))
  )
)
printf("%L\n" mkDivider("demolib" "divider"))

;; 第二个 cell：R2 的阻值用设计变量 r2（ADE 里就是这么扫参数的）
procedure( mkVarDivider (lib cell)
  let( (cv r1 r2)
    cv = dbOpenCellViewByType(lib cell "schematic" "schematic" "w")
    dbCreateTerm(cv "in"  "input")
    dbCreateTerm(cv "out" "output")
    dbCreateTerm(cv "gnd" "inputOutput")
    r1 = dbCreateInst(cv "vlightLib res" "R1" list(0 0)   "R0")
    r2 = dbCreateInst(cv "vlightLib res" "R2" list(0 -40) "R0")
    dbReplaceProp(r1 "r" "1k")
    dbReplaceProp(r2 "r" "r2")
    dbCreateConnByName( car(r1~>instTerms)  "in")
    dbCreateConnByName( cadr(r1~>instTerms) "out")
    dbCreateConnByName( car(r2~>instTerms)  "out")
    dbCreateConnByName( cadr(r2~>instTerms) "gnd")
    dbSave(cv)
    dbClose(cv)
    sprintf(nil "%s/%s ok" lib cell)
  )
)
printf("%L\n" mkVarDivider("demolib" "divider_var"))
