// Generated for: spectre
// Generated on: Oct 23 18:12:51 2026
// Design library name: vlV01_a500
// Design cell name: tb
// Design view name: schematic
simulator lang=spectre
global 0
include "/eda/1P9M/TSMC065_1P9M/tsmcN65/../models/spectre/crn65gplus_2d5_lk_v1d0.scs" section=tt_bip
include "/eda/1P9M/TSMC065_1P9M/tsmcN65/../models/spectre/crn65gplus_2d5_lk_v1d0.scs" section=tt_dio
include "/eda/1P9M/TSMC065_1P9M/tsmcN65/../models/spectre/crn65gplus_2d5_lk_v1d0.scs" section=tt_dio_33
include "/eda/1P9M/TSMC065_1P9M/tsmcN65/../models/spectre/crn65gplus_2d5_lk_v1d0.scs" section=tt_mim
include "/eda/1P9M/TSMC065_1P9M/tsmcN65/../models/spectre/crn65gplus_2d5_lk_v1d0.scs" section=tt_dio_dnw
include "/eda/1P9M/TSMC065_1P9M/tsmcN65/../models/spectre/crn65gplus_2d5_lk_v1d0.scs" section=tt_dio_18
include "/eda/1P9M/TSMC065_1P9M/tsmcN65/../models/spectre/crn65gplus_2d5_lk_v1d0.scs" section=tt_bip_npn
include "/eda/1P9M/TSMC065_1P9M/tsmcN65/../models/spectre/crn65gplus_2d5_lk_v1d0.scs" section=tt_33
include "/eda/1P9M/TSMC065_1P9M/tsmcN65/../models/spectre/crn65gplus_2d5_lk_v1d0.scs" section=tt_rfrtmom
include "/eda/1P9M/TSMC065_1P9M/tsmcN65/../models/spectre/crn65gplus_2d5_lk_v1d0.scs" section=tt_mos_cap_25
include "/eda/1P9M/TSMC065_1P9M/tsmcN65/../models/spectre/crn65gplus_2d5_lk_v1d0.scs" section=tt_18
include "/eda/1P9M/TSMC065_1P9M/tsmcN65/../models/spectre/crn65gplus_2d5_lk_v1d0.scs" section=tt_disres
include "/eda/1P9M/TSMC065_1P9M/tsmcN65/../models/spectre/crn65gplus_2d5_lk_v1d0.scs" section=tt_res
include "/eda/1P9M/TSMC065_1P9M/tsmcN65/../models/spectre/crn65gplus_2d5_lk_v1d0.scs" section=tt_dio_na
include "/eda/1P9M/TSMC065_1P9M/tsmcN65/../models/spectre/crn65gplus_2d5_lk_v1d0.scs" section=tt_rfmos_33
include "/eda/1P9M/TSMC065_1P9M/tsmcN65/../models/spectre/crn65gplus_2d5_lk_v1d0.scs" section=tt_dio_hvt
include "/eda/1P9M/TSMC065_1P9M/tsmcN65/../models/spectre/crn65gplus_2d5_lk_v1d0.scs" section=tt_rfmvar
include "/eda/1P9M/TSMC065_1P9M/tsmcN65/../models/spectre/crn65gplus_2d5_lk_v1d0.scs" section=tt_rfmos_18
include "/eda/1P9M/TSMC065_1P9M/tsmcN65/../models/spectre/crn65gplus_2d5_lk_v1d0.scs" section=tt_na
include "/eda/1P9M/TSMC065_1P9M/tsmcN65/../models/spectre/crn65gplus_2d5_lk_v1d0.scs" section=tt_dio_na33
include "/eda/1P9M/TSMC065_1P9M/tsmcN65/../models/spectre/crn65gplus_2d5_lk_v1d0.scs" section=tt_dio_lvt
include "/eda/1P9M/TSMC065_1P9M/tsmcN65/../models/spectre/crn65gplus_2d5_lk_v1d0.scs" section=tt_rfres_sa
include "/eda/1P9M/TSMC065_1P9M/tsmcN65/../models/spectre/crn65gplus_2d5_lk_v1d0.scs" section=tt_na33
include "/eda/1P9M/TSMC065_1P9M/tsmcN65/../models/spectre/crn65gplus_2d5_lk_v1d0.scs" section=tt_dio_esd
include "/eda/1P9M/TSMC065_1P9M/tsmcN65/../models/spectre/crn65gplus_2d5_lk_v1d0.scs" section=tt_rfmim
include "/eda/1P9M/TSMC065_1P9M/tsmcN65/../models/spectre/crn65gplus_2d5_lk_v1d0.scs" section=tt_dio_25od33
include "/eda/1P9M/TSMC065_1P9M/tsmcN65/../models/spectre/crn65gplus_2d5_lk_v1d0.scs" section=tt_25od33
include "/eda/1P9M/TSMC065_1P9M/tsmcN65/../models/spectre/crn65gplus_2d5_lk_v1d0.scs" section=tt
include "/eda/1P9M/TSMC065_1P9M/tsmcN65/../models/spectre/crn65gplus_2d5_lk_v1d0.scs" section=tt_mos_cap
include "/eda/1P9M/TSMC065_1P9M/tsmcN65/../models/spectre/crn65gplus_2d5_lk_v1d0.scs" section=tt_dio_25
include "/eda/1P9M/TSMC065_1P9M/tsmcN65/../models/spectre/crn65gplus_2d5_lk_v1d0.scs" section=tt_dio_25ud18
include "/eda/1P9M/TSMC065_1P9M/tsmcN65/../models/spectre/crn65gplus_2d5_lk_v1d0.scs" section=tt_25
include "/eda/1P9M/TSMC065_1P9M/tsmcN65/../models/spectre/crn65gplus_2d5_lk_v1d0.scs" section=tt_rfmos
include "/eda/1P9M/TSMC065_1P9M/tsmcN65/../models/spectre/crn65gplus_2d5_lk_v1d0.scs" section=tt_25ud18
include "/eda/1P9M/TSMC065_1P9M/tsmcN65/../models/spectre/crn65gplus_2d5_lk_v1d0.scs" section=tt_dio_na25od33
include "/eda/1P9M/TSMC065_1P9M/tsmcN65/../models/spectre/crn65gplus_2d5_lk_v1d0.scs" section=tt_rfjvar
include "/eda/1P9M/TSMC065_1P9M/tsmcN65/../models/spectre/crn65gplus_2d5_lk_v1d0.scs" section=tt_rfmos_25
include "/eda/1P9M/TSMC065_1P9M/tsmcN65/../models/spectre/crn65gplus_2d5_lk_v1d0.scs" section=tt_rtmom
include "/eda/1P9M/TSMC065_1P9M/tsmcN65/../models/spectre/crn65gplus_2d5_lk_v1d0.scs" section=tt_na25od33
include "/eda/1P9M/TSMC065_1P9M/tsmcN65/../models/spectre/crn65gplus_2d5_lk_v1d0.scs" section=tt_dio_na25
include "/eda/1P9M/TSMC065_1P9M/tsmcN65/../models/spectre/crn65gplus_2d5_lk_v1d0.scs" section=tt_rfres_rpo
include "/eda/1P9M/TSMC065_1P9M/tsmcN65/../models/spectre/crn65gplus_2d5_lk_v1d0.scs" section=tt_hvt
include "/eda/1P9M/TSMC065_1P9M/tsmcN65/../models/spectre/crn65gplus_2d5_lk_v1d0.scs" section=tt_rfind
include "/eda/1P9M/TSMC065_1P9M/tsmcN65/../models/spectre/crn65gplus_2d5_lk_v1d0.scs" section=tt_rfmvar_25
include "/eda/1P9M/TSMC065_1P9M/tsmcN65/../models/spectre/crn65gplus_2d5_lk_v1d0.scs" section=tt_na25
include "/eda/1P9M/TSMC065_1P9M/tsmcN65/../models/spectre/crn65gplus_2d5_lk_v1d0.scs" section=tt_lvt

// Library name: vlV01_a500
// Cell name: tb
// View name: schematic
M0 (net4 net2 net1 net3) nch l=60n w=500n m=1 nf=1 sd=200n ad=3.5e-14 \
        as=3.5e-14 pd=750n ps=750n nrd=0.5 nrs=0.5 sa=175n sb=175n sca=0 \
        scb=0 scc=0
simulatorOptions options psfversion="1.4.0" reltol=1e-3 vabstol=1e-6 \
    iabstol=1e-12 temp=27 tnom=27 scalem=1.0 scale=1.0 gmin=1e-12 rforce=1 \
    maxnotes=5 maxwarns=5 digits=5 cols=80 pivrel=1e-3 \
    sensfile="../psf/sens.output" checklimitdest=psf
modelParameter info what=models where=rawfile
element info what=inst where=rawfile
outputParameter info what=output where=rawfile
designParamVals info what=parameters where=rawfile
primitives info what=primitives where=rawfile
subckts info what=subckts where=rawfile
saveOptions options save=allpub
