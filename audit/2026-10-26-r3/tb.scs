// Design: vlV01_a500/tb
simulator lang=spectre
global 0
include "/eda/1P9M/TSMC065_1P9M/tsmcN65/../models/spectre/crn65gplus_2d5_lk_v1d0.scs" section=tt_bip
include "/eda/1P9M/TSMC065_1P9M/tsmcN65/../models/spectre/crn65gplus_2d5_lk_v1d0.scs" section=tt_dio
include "/eda/1P9M/TSMC065_1P9M/tsmcN65/../models/spectre/crn65gplus_2d5_lk_v1d0.scs" section=tt_dio_33
include "/eda/1P9M/TSMC065_1P9M/tsmcN65/../models/spectre/crn65gplus_2d5_lk_v1d0.scs" section=tt_mim
include "/eda/1P9M/TSMC065_1P9M/tsmcN65/../models/spectre/crn65gplus_2d5_lk_v1d0.scs" section=tt_dio_dnw
include "/eda/1P9M/TSMC065_1P9M/tsmcN65/../models/spectre/crn65gplus_2d5_lk_v1d0.scs" section=tt_dio_18
include "/eda/1P9M/TSMC065_1P9M/tsmcN65/../models/spectre/crn65gplus_2d5_lk_v1d0.scs" section=tt_bip_npn
include "/eda/1P9M/TSMC065_1P9M/tsmcN65/../models/spectre/crn65gplus_2d5_lk_v1d0.scs" section=tt_33
include "/eda/1P9M/TSMC065_1P9M/tsmcN65/../models/spectre/crn65gplus_2d5_lk_v1d0.scs" section=tt_rfrtmom
include "/eda/1P9M/TSMC065_1P9M/tsmcN65/../models/spectre/crn65gplus_2d5_lk_v1d0.scs" section=tt_mos_cap_25
include "/eda/1P9M/TSMC065_1P9M/tsmcN65/../models/spectre/crn65gplus_2d5_lk_v1d0.scs" section=tt_18
include "/eda/1P9M/TSMC065_1P9M/tsmcN65/../models/spectre/crn65gplus_2d5_lk_v1d0.scs" section=tt_disres
include "/eda/1P9M/TSMC065_1P9M/tsmcN65/../models/spectre/crn65gplus_2d5_lk_v1d0.scs" section=tt_res
include "/eda/1P9M/TSMC065_1P9M/tsmcN65/../models/spectre/crn65gplus_2d5_lk_v1d0.scs" section=tt_dio_na
include "/eda/1P9M/TSMC065_1P9M/tsmcN65/../models/spectre/crn65gplus_2d5_lk_v1d0.scs" section=tt_rfmos_33
include "/eda/1P9M/TSMC065_1P9M/tsmcN65/../models/spectre/crn65gplus_2d5_lk_v1d0.scs" section=tt_dio_hvt
include "/eda/1P9M/TSMC065_1P9M/tsmcN65/../models/spectre/crn65gplus_2d5_lk_v1d0.scs" section=tt_rfmvar
include "/eda/1P9M/TSMC065_1P9M/tsmcN65/../models/spectre/crn65gplus_2d5_lk_v1d0.scs" section=tt_rfmos_18
include "/eda/1P9M/TSMC065_1P9M/tsmcN65/../models/spectre/crn65gplus_2d5_lk_v1d0.scs" section=tt_na
include "/eda/1P9M/TSMC065_1P9M/tsmcN65/../models/spectre/crn65gplus_2d5_lk_v1d0.scs" section=tt_dio_na33
include "/eda/1P9M/TSMC065_1P9M/tsmcN65/../models/spectre/crn65gplus_2d5_lk_v1d0.scs" section=tt_dio_lvt
include "/eda/1P9M/TSMC065_1P9M/tsmcN65/../models/spectre/crn65gplus_2d5_lk_v1d0.scs" section=tt_rfres_sa
include "/eda/1P9M/TSMC065_1P9M/tsmcN65/../models/spectre/crn65gplus_2d5_lk_v1d0.scs" section=tt_na33
include "/eda/1P9M/TSMC065_1P9M/tsmcN65/../models/spectre/crn65gplus_2d5_lk_v1d0.scs" section=tt_dio_esd
include "/eda/1P9M/TSMC065_1P9M/tsmcN65/../models/spectre/crn65gplus_2d5_lk_v1d0.scs" section=tt_rfmim
include "/eda/1P9M/TSMC065_1P9M/tsmcN65/../models/spectre/crn65gplus_2d5_lk_v1d0.scs" section=tt_dio_25od33
include "/eda/1P9M/TSMC065_1P9M/tsmcN65/../models/spectre/crn65gplus_2d5_lk_v1d0.scs" section=tt_25od33
include "/eda/1P9M/TSMC065_1P9M/tsmcN65/../models/spectre/crn65gplus_2d5_lk_v1d0.scs" section=tt
include "/eda/1P9M/TSMC065_1P9M/tsmcN65/../models/spectre/crn65gplus_2d5_lk_v1d0.scs" section=tt_mos_cap
include "/eda/1P9M/TSMC065_1P9M/tsmcN65/../models/spectre/crn65gplus_2d5_lk_v1d0.scs" section=tt_dio_25
include "/eda/1P9M/TSMC065_1P9M/tsmcN65/../models/spectre/crn65gplus_2d5_lk_v1d0.scs" section=tt_dio_25ud18
include "/eda/1P9M/TSMC065_1P9M/tsmcN65/../models/spectre/crn65gplus_2d5_lk_v1d0.scs" section=tt_25
include "/eda/1P9M/TSMC065_1P9M/tsmcN65/../models/spectre/crn65gplus_2d5_lk_v1d0.scs" section=tt_rfmos
include "/eda/1P9M/TSMC065_1P9M/tsmcN65/../models/spectre/crn65gplus_2d5_lk_v1d0.scs" section=tt_25ud18
include "/eda/1P9M/TSMC065_1P9M/tsmcN65/../models/spectre/crn65gplus_2d5_lk_v1d0.scs" section=tt_dio_na25od33
include "/eda/1P9M/TSMC065_1P9M/tsmcN65/../models/spectre/crn65gplus_2d5_lk_v1d0.scs" section=tt_rfjvar
include "/eda/1P9M/TSMC065_1P9M/tsmcN65/../models/spectre/crn65gplus_2d5_lk_v1d0.scs" section=tt_rfmos_25
include "/eda/1P9M/TSMC065_1P9M/tsmcN65/../models/spectre/crn65gplus_2d5_lk_v1d0.scs" section=tt_rtmom
include "/eda/1P9M/TSMC065_1P9M/tsmcN65/../models/spectre/crn65gplus_2d5_lk_v1d0.scs" section=tt_na25od33
include "/eda/1P9M/TSMC065_1P9M/tsmcN65/../models/spectre/crn65gplus_2d5_lk_v1d0.scs" section=tt_dio_na25
include "/eda/1P9M/TSMC065_1P9M/tsmcN65/../models/spectre/crn65gplus_2d5_lk_v1d0.scs" section=tt_rfres_rpo
include "/eda/1P9M/TSMC065_1P9M/tsmcN65/../models/spectre/crn65gplus_2d5_lk_v1d0.scs" section=tt_hvt
include "/eda/1P9M/TSMC065_1P9M/tsmcN65/../models/spectre/crn65gplus_2d5_lk_v1d0.scs" section=tt_rfind
include "/eda/1P9M/TSMC065_1P9M/tsmcN65/../models/spectre/crn65gplus_2d5_lk_v1d0.scs" section=tt_rfmvar_25
include "/eda/1P9M/TSMC065_1P9M/tsmcN65/../models/spectre/crn65gplus_2d5_lk_v1d0.scs" section=tt_na25
include "/eda/1P9M/TSMC065_1P9M/tsmcN65/../models/spectre/crn65gplus_2d5_lk_v1d0.scs" section=tt_lvt

// vlV01_a500/tb/schematic
M0 (net4 net2 net1 net3) nch l=60n w=500n m=1 nf=1
simulatorOptions options temp=27

VD (net4 0) vsource dc=1.2
VG (net2 0) vsource dc=0.6 type=pulse v1=0.6 v2=0.9 delay=0 rise=10p width=20n period=40n
VS (net1 0) vsource dc=0
VB (net3 0) vsource dc=0
op1 dc
sw1 dc dev=VG param=dc start=0 stop=1.2 step=0.1
tr1 tran stop=40n maxstep=0.2n
simulatorOptions options temp=27 reltol=1e-4
