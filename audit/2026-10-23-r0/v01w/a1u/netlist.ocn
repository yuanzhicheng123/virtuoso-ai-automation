simulator('spectre)
design("vlV01_a1u" "tb" "schematic")
createNetlist(?recreateAll t)
exit
