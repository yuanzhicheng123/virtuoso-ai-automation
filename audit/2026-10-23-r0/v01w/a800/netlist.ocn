simulator('spectre)
design("vlV01_a800" "tb" "schematic")
createNetlist(?recreateAll t)
exit
