simulator('spectre)
design("vlM1" "tb" "schematic")
createNetlist(?recreateAll t)
exit
