(let (cv inst d g s b)
  (ddCreateLib "vlM1" "./vlM1")
  (setq cv (dbOpenCellViewByType "vlM1" "tb" "schematic" "schematic" "w"))
  (setq inst (dbCreateInstByMasterName cv "tsmcN65" "nch" "symbol" "M0" 0:0 "R0"))
  (dbReplaceProp inst "w" "string" "1u")
  (dbReplaceProp inst "l" "string" "60n")
  (setq d (dbCreateNet cv "D")) (setq g (dbCreateNet cv "G"))
  (setq s (dbCreateNet cv "S")) (setq b (dbCreateNet cv "B"))
  (dbCreateConnByName d inst "D")
  (dbCreateConnByName g inst "G")
  (dbCreateConnByName s inst "S")
  (dbCreateConnByName b inst "B")
  (dbCreateLine cv (list "text" "drawing") (list 0:0 2:0))
  (printf "@@cv=%L@@\n" cv)
  (printf "@@inst=%L@@\n" inst)
  (printf "@@insts=%L@@\n" length(cv~>instances))
  (printf "@@nets=%L@@\n" length(cv~>nets))
  (printf "@@check=%L@@\n" (schCheck cv))
  (printf "@@save=%L@@\n" (dbSave cv))
  (dbClose cv)
  (printf "@@done=t@@\n"))
