(let (cv cdf prm i1 r)
  (ddCreateLib "vlW" "./vlW")
  (setq cv (dbOpenCellViewByType "vlW" "tb2" "schematic" "schematic" "w"))
  (setq i1 (dbCreateInstByMasterName cv "tsmcN65" "nch" "symbol" "M0" 0:0 "R0"))
  (setq cdf (cdfGetInstCDF i1))
  (printf "@@cdf=%L@@\n" cdf)
  (setq prm (cdfFindParamByName cdf "w"))
  (printf "@@prm=%L@@\n" prm)
  (when prm
    (printf "@@p_name=%L@@\n" prm~>name)
    (printf "@@p_type=%L@@\n" prm~>paramType)
    (printf "@@p_def=%L@@\n" prm~>defValue)
    (printf "@@p_val=%L@@\n" prm~>value)
    (printf "@@p_set=%L@@\n" (setq r (errset (prm~>value = "1u"))))
    (printf "@@p_val2=%L@@\n" prm~>value)
    (printf "@@upd=%L@@\n" (errset (cdfUpdateInstParam i1)))
    (printf "@@prop=%L@@\n" (dbGetPropByName i1 "w"))
    (printf "@@instw=%L@@\n" i1~>w))
  (printf "@@save=%L@@\n" (dbSave cv))
  (dbClose cv)
  (printf "@@done=t@@\n"))
