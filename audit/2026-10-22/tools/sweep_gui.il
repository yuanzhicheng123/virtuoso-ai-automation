(ddCreateLib "vlPy" "./vlPy")
(dbOpenCellViewByType "vlPy" "probe" "schematic" "schematic" "a")
(deOpenCellView "vlPy" "probe" "schematic" "schematic" nil "a")
(sleep 2)
(let (p)
  (setq p (outfile "/tmp/vl_is_gui.txt"))
  (foreach sym '(ALIAS
DATA
ERC
IDC
IF
IS
IT
LVS
MP
Mu
Mu_prime
NG
OP
OPT
OS
OT
PN
Rn
SIMULATOR
VAR
VDC
VF
VN
VN2
VNP
VNPP
VPD
VS
VT
aaSP
abGetAssistant
abGetCurrentIncompleteNetFilter
abHiFindMarker
abSetColorOnSelection
abSetIncompleteNetFilter
abeBlockagesFromCellView
abeBoundariesFromCellView
abeClearLayer
abeDone
abeElapsedTime
abeInit
abeIslandIterator
abeLayerAbut
abeLayerAnd
abeLayerAndNot
abeLayerAvoid
abeLayerFromCellView
abeLayerFromFigSet
abeLayerFromNet
abeLayerFromShapes
abeLayerGrow
abeLayerInside
abeLayerMergeTiles
abeLayerOr
abeLayerOrPtArray
abeLayerOutside
abeLayerShrink
abeLayerSize
abeLayerStraddle
abeLayerToBlockages
abeLayerToCellView
abeLayerToHilightSet
abeLayerTouch
abeLayerXor
abeMTdebug
abeNewLayer
abeRemoveLayer
abeRunQueue
abeShapesInside
abeShapesOutside
abeTileIterator
abs
absAbstract
absAttachTechLib
absCopyBinOptions
absDeleteBin
absDeleteBinMoveCellsTo
absDeselectAllBins
absDeselectBin
absDeselectBinFrom
absDeselectCell
absDeselectCellFrom
absDeselectCells
absDeselectCellsInList
absDisableUpdate
absDistributeCells
absEnableUpdate
absExit
absExportLEF
absExportOptions
absExportReport
absExtract
absGetBinOption
absGetBinType
absGetBins
absGetCellProp
absGetLibrary
absGetOption
absGetSelectedBins
absGetSelectedCells
absGetTerminalProp
absImportCTLF
absImportDEF
absImportGDS
absImportLEF
absImportLogical
absImportOasis
absImportOptions
absImportVerilog
absMoveSelectedCellsToBin
absNewBin
absPins
absRenameBin
absRevalidateSelectedCells
absSelect
absSelectAllBins
absSelectBin
absSelectBinFrom
absSelectCell
absSelectCellFrom
absSelectCells
absSelectCellsInList
absSetBinOption
absSetCellProp
absSetLibrary
absSetOption
absSetTerminalProp
absSort
absVerify
absVersion
abs_jitter
ac
acdlArtPrintIncludedNetlist
acdlCurrentInstName
acos
acosh
add1
addCheck
addDefstructClass
addDependent
addPoint
addSubwindow
addSubwindowTitle
addTitle
addToExportList
addToNamespace
addWaveLabel
addWindowLabel
adpInitFloorPlan
adpnlSetEnv
adtFFT
adtIFFT
aedCopyCDF
aedDeleteCDF
aedEditCDF
aelCheckRange
aelDisplayOPParam
aelEngNotation
aelEnvCompile
aelEnvCreate
aelEnvExecute
aelEnvFreeCompExpr
aelEnvGetErrStr
aelEnvGetGlobal
aelEnvInterpret
aelEnvListDeferredFuncs
aelEnvListDeferredGlobals
aelEnvListExprFuncs
aelEnvListExprGlobals
aelEnvListFuncs
aelEnvListGlobals
aelEnvListGlobalsValues
aelEnvName
aelEnvSetGlobalList
aelEnvSetGlobals
aelGetSignifDigits
aelNumber
aelPopSignifDigits
aelPushSignifDigits
aelSetLineage
aelSignum
aelStrDblNotation
aelSuffixNotation
aelSuffixWithUnits
aelSumOPParam
ahdlUpdateViewInfo
alias
allocateInstance
almDefineParam_accuracyMode
almDefineParam_additionalParam
almDefineParam_fq
almDefineParam_noiseParaLabel
almDefineParam_nportFileB
almDefineParam_otherParaLabel
almDefineParam_tranAdvanParaLabel
almDefineParam_tranParaLabel
almGetModuleName
almGetNamePrefix
almGetNetlistProcedure
almGetNetlistType
almGetOpPointParamMap
almGetOtherParameterList
almGetParameterList
almGetPropMappingList
almGetStringParameterList
almGetTerminalList
almGetTerminalMap
almGetViewInfoNameList
almHasViewInformation
almSetNamePrefix
almSetNetlistProcedure
almSetOpPointParamMap
almSetOtherParameterList
almSetParameterList
almSetPropMappingList
almSetStringParameterList
almSetTerminalList
almSetTerminalMap
alphaNumCmp
alphalessp
amsOSSUnlExecutePostNetlistTrigger
amsUpdateTextviews
amseGeneralSetupForm
amseQuickSetupForm
analog2Digital
analysis
analysisAttributeLocks
ancAdjustNameCase
ancGetSimInstName
and
annLoadAnnotationData
annPinCurrentInfoBalloon
annRetrieveFromEffectiveCDF
annSaveAnnotationData
annToggleInfoBalloonVisibilityStatus
ansAnalogRegCDFsimInfo
ansCdlCompPrim
ansCdlGetMultiplicity
ansCdlGetSegmentConnections
ansCdlGetSegmentInfo
ansCdlGetSegmentInstParams
ansCdlGetSimPropValue
ansCdlHnlPrintInst
ansCdlPrintConnections
ansCdlPrintInheritedParams
ansCdlPrintInstName
ansCdlPrintInstParams
ansCdlPrintInstProps
ansCdlPrintModelName
ansCdlPrintModuleName
ansCdlPrintString
ansCdlPrintSwitchPCellInst
ansCdlPrintSwitchPCellInstParam
ansCdlPrintSwitchPCellSubCircuit
ansCdlPrintSwitchPCellSubcktConn
ansiDefmethod
apCustomPDKSettings
apEnableM0OnFlow
apPDKSetupGetCdsEnvs
apPDKSetupGetFillParams
apPDKSetupGetModgenDummyParams
apPDKSetupGetParamFunc
apPDKSetupGetParamList
apPDKSetupGetRegProcs
apPDKSetupGetVtNameList
apPlaceAuto
apPlaceAutoMatureNode
apResetPDKSetup
apSnapInsts
appTrigger
append
append1
appendPath
appendWaves
apply
applyEnterFun
argc
arglist
argv
armSetCalc
arrayp
arrayref
artBlankString
artClose
artCloseAllFiles
artCurrentInstSimName
artEnableAnnotationBalloon
artFlush
artFprintf
artGenerateHierSymbolCDF
artGetCdfTargetCV
artGetCellViewDesignVarList
artInvalidateAmap
artListOpenFiles
artListToWaveform
artMakeString
artMakeStringPrec15
artOutfile
asiAddAnalysis
asiAddAnalysisField
asiAddAnalysisOption
asiAddDesignVarList
asiAddEnvOption
asiAddFlowchartLink
asiAddFlowchartStep
asiAddKeepOption
asiAddModelLibSelection
asiAddOceanAlias
asiAddSimOption
asiAddVerilogArgs
asiAnalogAutoloadProc
asiChangeAnalysis
asiChangeAnalysisField
asiChangeAnalysisOption
asiChangeAnalysisOptionFormProperties
asiChangeEnvOption
asiChangeEnvOptionFormProperties
asiChangeFlowchartStep
asiChangeKeepOption
asiChangeKeepOptionFormProperties
asiChangeSimOption
asiChangeSimOptionFormProperties
asiCheck
asiCheckAcEnabledWhenNoiseEnabled
asiCheckAnalysis
asiCheckBlank
asiCheckBlankInstExists
asiCheckBlankNetExists
asiCheckBlankNumeric
asiCheckBlankNumericGeq
asiCheckBlankNumericGreater
asiCheckBlankNumericLeq
asiCheckBlankNumericNequal
asiCheckDesignVariable
asiCheckDigitalSimulationSuccess
asiCheckExpression
asiCheckExpressionGreater
asiCheckMultipleGreater
asiCheckSimulationSuccess
asiCloseOceanScript
asiConstructDigitalNetlist
asiCreateAnalysisField
asiCreateAnalysisOption
asiCreateCdsenvFile
asiCreateFlowchart
asiCreateFormatter
asiCreateIncludeStatementFile
asiCreateLogFileVerilog
asiDcStore
asiDefineDataAccessFunction
asiDefineDataMappingFunction
asiDeleteAnalysis
asiDeleteAnalysisField
asiDeleteAnalysisOption
asiDeleteEnvOption
asiDeleteFlowchartLink
asiDeleteFlowchartStep
asiDeleteKeepOption
asiDeleteSimOption
asiDigitalSimAutoloadProc
asiDisableAnalysis
asiDisplayAnalysis
asiDisplayAnalysisField
asiDisplayAnalysisOption
asiDisplayAnalysisOptionFormProperties
asiDisplayEnvOption
asiDisplayEnvOptionFormProperties
asiDisplayFlowchart
asiDisplayHighPerformanceOption
asiDisplayKeepOption
asiDisplayKeepOptionFormProperties
asiDisplayNetlistOption
asiDisplaySimOption
asiDisplaySimOptionFormProperties
asiEditDigitalStimulus
asiEnableAnalysis
asiExecuteFlowchart
asiExtractQRCTechPathFromDSPF
asiExtractQRCTechPathFromSession
asiFinalNetlist
asiFormatAnalysis
asiFormatAnalysisList
asiFormatControlStmts
asiFormatDefinitionFileList
asiFormatDesignVarList
asiFormatGraphicalStimuli
asiFormatGraphicalStimulusFileList
asiFormatInitCond
asiFormatKeepList
asiFormatModelLibSelectionList
asiFormatNodeSet
asiFormatSimulatorOptions
asiFormatSpecialParameterForRel
asiFormatTextStimulusFileList
asiGetAdvAnalysis
asiGetAnalogKeepList
asiGetAnalogRunDir
asiGetAnalogSimulator
asiGetAnalysis
asiGetAnalysisField
asiGetAnalysisFieldChoices
asiGetAnalysisFieldList
asiGetAnalysisFieldVal
asiGetAnalysisFormFieldChoices
asiGetAnalysisFormFieldVal
asiGetAnalysisFormObj
asiGetAnalysisName
asiGetAnalysisNameList
asiGetAnalysisOptionList
asiGetAnalysisOptionSendMethod
asiGetAnalysisOptionVal
asiGetAnalysisParamNameList
asiGetAnalysisSigList
asiGetAnalysisSimFieldList
asiGetAnalysisType
asiGetAvailableMCOptions
asiGetCalcResultsDir
asiGetCommandFooter
asiGetCommandLineOption
asiGetCurrentSession
asiGetDefinitionFileList
asiGetDesignCellName
asiGetDesignLibName
asiGetDesignVarList
asiGetDesignVarListWithOriginalExpressions
asiGetDesignViewName
asiGetDigitalCommandLineOption
asiGetDigitalKeepList
asiGetDigitalNetlistFileName
asiGetDigitalRunDir
asiGetDigitalSimExecName
asiGetDigitalSimulator
asiGetDigitalSimulatorLogFileName
asiGetDigitalStimulusFileName
asiGetDrlData
asiGetEMIROptionVal
asiGetEnabledAnalysisList
asiGetEnvOptionChoices
asiGetEnvOptionVal
asiGetFlowchart
asiGetFormFieldChoices
asiGetFormFieldVal
asiGetFormattedVal
asiGetFormatter
asiGetHighPerformanceOptionVal
asiGetId
asiGetIterationUpdateFile
asiGetKeepList
asiGetKeepOptionChoices
asiGetKeepOptionVal
asiGetLogFileList
asiGetMarchList
asiGetModelLibFile
asiGetModelLibSection
asiGetModelLibSelectionList
asiGetNetlistDir
asiGetNetlistFileListToSymLink
asiGetNetlistFormatterClass
asiGetNetlistOption
asiGetNetworkId
asiGetOutputList
asiGetPageCallBack
asiGetPlotList
asiGetPredefinedCommandLineOption
asiGetPsfDir
asiGetReservedWordList
asiGetResultsNetlistDir
asiGetResultsPsfDir
asiGetSelObjName
asiGetSelObjType
asiGetSelObjValue
asiGetSession
asiGetSimCommandLineOrder
asiGetSimExecName
asiGetSimInputFileList
asiGetSimInputFileName
asiGetSimInputFileSuffix
asiGetSimName
asiGetSimOptionChoices
asiGetSimOptionNameList
asiGetSimOptionSendMethod
asiGetSimOptionVal
asiGetSimulationRunCommand
asiGetSimulatorList
asiGetSimulatorSrcList
asiGetStimulusGlobals
asiGetStimulusInputs
asiGetSupportedMCOptions
asiGetTextStimulusFileList
asiGetTool
asiGetTopCellView
asiGetVerilogCommandLineOption
asiGetVerilogHost
asiGetVerilogHostMode
asiInitAdvAnalysis
asiInitAnalysis
asiInitDataAccessFunction
asiInitEnvOption
asiInitMixedKeepOption
asiInitSimOption
asiInitVerilog
asiInitVerilogEnvOption
asiInitVerilogFNLEnvOption
asiInitVerilogHNLEnvOption
asiInitVerilogSimOption
asiInitialize
asiInitializeNetlisterMixed
asiInterruptSim
asiInvalidateControlStmts
asiInvalidateFlowchartStep
asiIsAnalysisEnabled
asiIsCaseSensitive
asiIsConfigDesign
asiIsICLPSupported
asiLoadState
asiMapInstanceName
asiMapNetName
asiMapOutputName
asiMapTerminalName
asiNeedSuffixEvaluation
asiNetlist
asiNetlistMixed
asiOpenOceanScript
asiPartitionDesign
asiPrepareDigitalSimulation
asiQuitSimulator
asiRawNetlist
asiRegCallBackOnSimComp
asiRegCallBackOnSimCompForDist
asiRegisterTool
asiRemoveAllModelLibSelection
asiRunSimulation
asiSaveState
asiSelectAnalysisCompParam
asiSelectAnalysisInst
asiSelectAnalysisNet
asiSelectAnalysisSource
asiSelectInst
asiSelectNet
asiSelectSourceInst
asiSelectTerm
asiSelectTermNet
asiSendAnalysis
asiSendControlStmts
asiSendDesignVars
asiSendInitCond
asiSendInitFile
asiSendKeepList
asiSendModelPath
asiSendNetlist
asiSendNodeSets
asiSendOptions
asiSendRestore
asiSendSim
asiSendUpdateFile
asiSetAnalogSimulator
asiSetAnalysisFieldChoices
asiSetAnalysisFieldVal
asiSetAnalysisFormFieldChoices
asiSetAnalysisFormFieldVal
asiSetAnalysisFormWidth
asiSetAnalysisOptionChoices
asiSetAnalysisOptionFormProperties
asiSetAnalysisOptionVal
asiSetDesignVarList
asiSetDigitalSimulator
asiSetEMIROptionVal
asiSetEnvOptionChoices
asiSetEnvOptionVal
asiSetFormFieldChoices
asiSetFormFieldVal
asiSetHighPerformanceOptionVal
asiSetHostOptions
asiSetKeepList
asiSetKeepOptionChoices
asiSetKeepOptionVal
asiSetMarchList
asiSetNetlistFormatterClass
asiSetNetlistOption
asiSetPageCallBack
asiSetPlotList
asiSetProjectDirChangeSetup
asiSetSimOptionChoices
asiSetSimOptionVal
asiSetSyncFlag
asiSetValid
asiSetVerilogHost
asiSetVerilogHostMode
asiStmGenerateNetlist
asiStmGenerateWaveform
asiStmRunSimulation
asiStmSupportWaveformGeneration
asiTransientStore
asiUnRegCallBackOnSimComp
asiUnRegCallBackOnSimCompForDist
asiVerilogNetlistMoreCB
asiWriteOceanScript
asin
asinh
assert
atan
atan2
atanh
atof
atoi
atom
auCdl
auHiUltraPCell
auLvs
auLvsGetLabelSuffix
auProbeAddDevsForNet
avSwitch
average
awvAddSubwindow
awvAnalog2Digital
awvAppendExpression
awvAppendList
awvAppendWaveform
awvClearPlotWindow
awvClearSubwindowHistory
awvClearWindowHistory
awvCloseCalculator
awvCloseWindow
awvCloseWindowMenuCB
awvCreateBus
awvCreateBusFromWaveList
awvCreatePlotWindow
awvDeleteAllWaveforms
awvDeleteMarker
awvDeleteSubwindow
awvDeleteWaveform
awvDigital2Analog
awvDisableRedraw
awvDisplayDate
awvDisplayGrid
awvDisplaySubwindowTitle
awvDisplayTitle
awvEraseWindowMenuCB
awvEval
awvExitWindowFunctionAdd
awvExitWindowFunctionDel
awvExitWindowFunctionGet
awvEyeCross
awvGetAssertName
awvGetCurrentSubwindow
awvGetCurrentWindow
awvGetDisplayMode
awvGetDrawStatus
awvGetHiWindow
awvGetInitializationTimeout
awvGetLegendPos
awvGetOnSubwindowList
awvGetPlotStyle
awvGetScalarFromWave
awvGetSelectedTraceWaveforms
awvGetSmithModeType
awvGetStripNumberOfSelectedTrace
awvGetStripNumbersList
awvGetSubwindowList
awvGetSubwindowStripCount
awvGetSubwindowTitle
awvGetUnusedEntityList
awvGetWaveNameList
awvGetWindowList
awvGetWindowTitle
awvGetXAxisLabel
awvGetXAxisMajorDivisions
awvGetXAxisMinorDivisions
awvGetXAxisStepValue
awvGetXAxisUseStepValue
awvGetXMarkerNames
awvGetYAxisLabel
awvGetYAxisMajorDivisions
awvGetYAxisMinorDivisions
awvGetYAxisStepValue
awvGetYAxisUseStepValue
awvGetYMarkerNames
awvInitWindowFunctionAdd
awvInitWindowFunctionDel
awvInitWindowFunctionGet
awvIsPlotWindow
awvLoadCustomCalcFunction
awvLoadEyeMask
awvLoadMenuCB
awvLoadSharedCustomFunctionsFile
awvLoadWindow
awvLogXAxis
awvLogYAxis
awvPlaceAMarker
awvPlaceBMarker
awvPlaceBookmark
awvPlaceCircleMarker
awvPlacePointMarker
awvPlaceQContour
awvPlaceWaveformLabel
awvPlaceWindowLabel
awvPlaceXMarker
awvPlaceYMarker
awvPlotExpression
awvPlotList
awvPlotSignals
awvPlotSimpleExpression
awvPlotWaveform
awvPlotWaveformOption
awvPrintWaveform
awvRedisplaySubwindow
awvRedisplayWindow
awvRedrawWindowMenuCB
awvRefreshOutputPlotWindows
awvRemoveDate
awvRemoveLabel
awvRemoveSubwindowTitle
awvRemoveTitle
awvResetAllWindows
awvResetWindow
awvResumeViVA
awvRfLoadPull
awvSaveMenuCB
awvSaveToCSV
awvSaveWindow
awvSaveWindowImage
awvSetCurrentSubwindow
awvSetCurrentWindow
awvSetCursorPrompts
awvSetDisplayMode
awvSetDisplayStatus
awvSetInitializationTimeout
awvSetLegendPos
awvSetLegendWidth
awvSetOptionDefault
awvSetOptionValue
awvSetOrigin
awvSetPlotStyle
awvSetSmithModeType
awvSetSmithXLimit
awvSetSmithYLimit
awvSetUpdateStatus
awvSetWaveNameList
awvSetWaveformDisplayStatus
awvSetXAxisLabel
awvSetXAxisMajorDivisions
awvSetXAxisMinorDivisions
awvSetXAxisStepValue
awvSetXAxisUseStepValue
awvSetXLimit
awvSetXScale
awvSetYAxisLabel
awvSetYAxisMajorDivisions
awvSetYAxisMinorDivisions
awvSetYAxisStepValue
awvSetYAxisUseStepValue
awvSetYLimit
awvSetYRange
awvSimplePlotExpression
awvSmithAxisMenuCB
awvTableSignals
awvUpdateAllWindows
awvUpdateWindow
awvZoomFit
awvZoomGraphX
awvZoomGraphXY
awvZoomGraphY
axlAddJobPolicy
axlAddModelPermissibleSectionLists
axlAddOutputExpr
axlAddOutputSignal
axlAddOutputs
axlAddOutputsColumn
axlAddSpecToOutput
axlAttachJobPolicy
axlCloseSession
axlCloseSessionInWindow
axlCloseSetupDB
axlCommitSetupDB
axlCommitSetupDBAndHistoryAs
axlCommitSetupDBas
axlCorners
axlCreateSession
axlCustomADETestName
axlDeleteJobPolicy
axlDeleteNote
axlDeleteOutput
axlDeleteOutputsColumn
axlDetachJobPolicy
axlDiffSetup
axlExportOutputView
axlExportSetup
axlGetActiveSetup
axlGetAllCornersEnabled
axlGetAllParametersDisabled
axlGetAllSweepsEnabled
axlGetAllVarsDisabled
axlGetAttachedJobPolicy
axlGetCopyRefResultsOption
axlGetCorner
axlGetCornerCountForName
axlGetCornerDisabledTests
axlGetCornerNameForCurrentPointInRun
axlGetCorners
axlGetCornersForATest
axlGetCurrentHistory
axlGetCurrentResultSimulationHost
axlGetCurrentRunMode
axlGetCustomOutputResultMenu
axlGetDataViewHistoryUserMenu
axlGetElementParent
axlGetEnabled
axlGetEnabledGlobalVarPerTest
axlGetEnabledTests
axlGetHistory
axlGetHistoryCheckpoint
axlGetHistoryEntry
axlGetHistoryGroup
axlGetHistoryGroupChildren
axlGetHistoryGroupChildrenEntry
axlGetHistoryLock
axlGetHistoryName
axlGetHistoryPrefix
axlGetHistoryResults
axlGetJobPolicy
axlGetJobPolicyTypes
axlGetLocalResultsDir
axlGetMainSetupDB
axlGetModel
axlGetModelBlock
axlGetModelFile
axlGetModelGroup
axlGetModelGroupName
axlGetModelGroups
axlGetModelPermissibleSectionLists
axlGetModelSection
axlGetModelSections
axlGetModelTest
axlGetModels
axlGetNominalCornerEnabled
axlGetNominalCornerTestEnabled
axlGetNote
axlGetOrigTestToolArgs
axlGetOutputNotation
axlGetOutputSignificantDigits
axlGetOutputSuffix
axlGetOutputUnits
axlGetOutputUserDefinedData
axlGetOverwriteHistory
axlGetOverwriteHistoryName
axlGetParameter
axlGetParameterValue
axlGetParameters
axlGetParasiticParaLCV
axlGetParasiticRunMode
axlGetParasiticSchLCV
axlGetParasiticViewName
axlGetPointNetlistDir
axlGetPointPsfDir
axlGetPointRunDir
axlGetPointTroubleshootDir
axlGetPreRunScript
axlGetResultsLocation
axlGetReuseNetlist
axlGetRunData
axlGetRunDistributeOptions
axlGetRunMode
axlGetRunModes
axlGetRunOption
axlGetRunOptionName
axlGetRunOptionValue
axlGetRunOptions
axlGetRunStatus
axlGetScript
axlGetScriptPath
axlGetScripts
axlGetSessionCellName
axlGetSessionFromSetupDB
axlGetSessionLibName
axlGetSessionViewName
axlGetSessionWindowNumber
axlGetSetupDBDir
axlGetSetupInfo
axlGetSpec
axlGetSpecData
axlGetSpecWeight
axlGetSpecs
axlGetStatVars
axlGetTemperatureForCurrentPointInRun
axlGetTest
axlGetTestToolArgs
axlGetTests
axlGetToolSession
axlGetTopLevel
axlGetUseIncremental
axlGetUserDefinedOutputsColumns
axlGetVar
axlGetVarValue
axlGetVars
axlGetWCCCorner
axlGetWCCHistory
axlGetWCCRangeBound
axlGetWCCResult
axlGetWCCSpec
axlGetWCCSpecs
axlGetWCCTest
axlGetWCCTime
axlGetWCCVar
axlGetWCCVarMonotonicity
axlGetWCCVars
axlGetWYCSigmaTargetLimit
axlGetWindowSession
axlImportPreRunScript
axlImportSetup
axlIsICRPProcess
axlIsLocalResultsDir
axlIsSessionReadOnly
axlIsSimUsingStatParams
axlIsValidAXLSession
axlJPGUICusReadFromForm
axlJPGUICustDiffer
axlJPGUICustHIFields
axlJPGUICustHiddenSections
axlJPGUICustOffset
axlJPGUICustSelected
axlJPGUICustWriteToForm
axlJobIntfcDebugPrintf
axlJobIntfcDebugToFile
axlJobIntfcDebugp
axlJobIntfcExitMethod
axlJobIntfcHealthMethod
axlJobIntfcSetDebug
axlJobIntfcStartJobArrayMethod
axlJobIntfcStartMethod
axlLoadCorners
axlLoadCornersFromPcfToSetupDB
axlLoadHistory
axlLoadSetupState
axlMainAppSaveSetup
axlMapInstTermToNet
axlNewSetupDB
axlNewSetupDBLCV
axlNoSession
axlOpenResDB
axlOutputResult
axlOutputsExportToFile
axlOutputsImportFromFile
axlPlotAcrossDesignPoints
axlPutCorner
axlPutDisabledCorner
axlPutHistoryEntry
axlPutModel
axlPutModelGroup
axlPutNote
axlPutOutputNotation
axlPutOutputSignificantDigits
axlPutOutputSuffix
axlPutOutputUnits
axlPutRunOption
axlPutScript
axlPutTest
axlPutVar
axlReEvaluateHistory
axlReadHistoryResDB
axlReadResDB
axlRegisterCustomDeviceFilter
axlRegisterJobIntfc
axlRegisteredJPGUICust
axlRegisteredJobIntfcNames
axlRemoveElement
axlRemoveSetupState
axlRemoveSimulationResults
axlRenameOutputsColumn
axlResetActive
axlRestoreHistory
axlRunAllTests
axlRunAllTestsWithCallback
axlRunSimulation
axlSDBDebugPrint
axlSDBGetChild
axlSDBGetChildVal
axlSDBGetChildren
axlSDBGetExtension
axlSDBGetName
axlSDBGetValue
axlSDBHp
axlSDBPutExtension
axlSDBSetChild
axlSDBSetMultipleEntry
axlSDBSetValue
axlSaveJobPolicy
axlSaveSetup
axlSaveSetupState
axlSaveSetupToLib
axlSessionConnect
axlSessionDisconnect
axlSessionRegisterCreationCallback
axlSessionSignalList
axlSessionSignalSignature
axlSetAllCornersEnabled
axlSetAllParametersDisabled
axlSetAllSweepsEnabled
axlSetAllVarsDisabled
axlSetCopyRefResultsOption
axlSetCornerName
axlSetCornerTestEnabled
axlSetCurrentRunMode
axlSetDefaultCornerEnabled
axlSetDefaultVariables
axlSetDesignVariablePerTest
axlSetEnabled
axlSetHistoryLock
axlSetHistoryName
axlSetJobPolicyProperty
axlSetMainSetupDB
axlSetMainSetupDBLCV
axlSetModelBlock
axlSetModelFile
axlSetModelGroupName
axlSetModelPermissibleSectionLists
axlSetModelSection
axlSetModelTest
axlSetNominalCornerEnabled
axlSetNominalCornerTestEnabled
axlSetOutputUserDefinedData
axlSetOverwriteHistory
axlSetOverwriteHistoryName
axlSetParameter
axlSetParasiticRunMode
axlSetParasiticViewName
axlSetPreRunScript
axlSetPreRunScriptEnabled
axlSetReferenceHistoryItemName
axlSetReuseNetlistOption
axlSetRunDistributeOptions
axlSetRunOptionName
axlSetRunOptionValue
axlSetScriptPath
axlSetTestToolArgs
axlSetUseIncremental
axlSetWCCTime
axlSetWYCSigmaTargetLimit
axlSetupStates
axlShowPersistedQuestionDialog
axlStop
axlStopAll
axlStopAllJobs
axlStopJob
axlSuppressPersistedQuestionDialog
axlToolSetOpPointInfo
axlToolSetOriginalSetupOptions
axlToolSetSetupOptions
axlViewHistoryResults
axlWriteDatasheet
axlWriteDatasheetForm
axlWriteMonteCarloResultsCSV
axlWriteOceanScriptLCV
b1f
band
bandwidth
baseLine
bcdp
begin
bitfield
bitfield1
blankstrp
bnand
bndAddInstsBindingByName
bndAddObjectsBinding
bndGetBoundObjects
bndGetSiblingBoundObjects
bndRegRemoveDeviceGetSurvivingNet
bndRemoveInstBindingByName
bndRemoveObjectBinding
bndRemoveTermBindingByName
bndReplaceInstsBindingByName
bndReplaceObjectsBinding
bndReplaceTermsBindingByName
bndSetInstsBindingByName
bndSetObjectsBinding
bndSetTermsBindingByName
bndUnregRemoveDeviceGetSurvivingNet
bnor
bnot
booleanp
bor
bottomEdge
boundp
break
breakpt
breakptMethod
buildString
busTransition
bxnor
bxor
cPwrContour
cReflContour
calCalcInput
calCalculatorFormCB
calCreateSpecialFunction
calCreateSpecialFunctionsForm
calGetBuffer
calRegisterSpecialFunction
calSetBuffer
calSetCurrentTest
calSpecialFunctionInput
calcVal
calcValForRel
caliModeToggle
caliRestoreDefaultWindowSize
callAs
callInitProc
callNextMethod
callUserAutoInitProc
cancelEnterFun
captabSummary
car
case
caseq
cat
catch
ccBendConnector
ccConvertIntoCurvy
ccCopyFig
ccCreateConnectorWidthExpressionList
ccCreateCurve
ccCreateEllipse
ccCreateFacet
ccCreateLine
ccCreateLineSegment
ccCreatePath
ccCreatePie
ccCreatePolyCurve
ccCreatePolygon
ccCreateRect
ccCreateSurface
ccCreateSurfaceFromPath
ccCubicSplineConnector
ccCurveConnector
ccFindSurfaceFacet
ccGenFigs
ccGenOffsetFig
ccGetAll
ccGetCurveDerivative
ccGetCurveLength
ccGetCurvePoint
ccGetFromFig
ccGetPathBoundary
ccGetPathCenterLine
ccGetPathEdge
ccGetPolyCurveMinRadius
ccIsEnabled
ccIsLinearCurve
ccLayerAnd
ccLayerAndNot
ccLayerOffset
ccLayerOr
ccMirrorFacet
ccMoveFig
ccORE
ccORECompile
ccOREGetContext
ccOREGetContextObject
ccOREGetContexts
ccOREPurgeContext
ccOREPurgeContexts
ccOffsetPolyCurve
ccOrientCurve
ccRemoveFigs
ccRenameFacet
ccReversePolyCurve
ccSmoothenFig
ccSmoothenPolyCurve
ccSpiralConnector
ccTransformFacet
ccTransformPolyCurve
ccTromboneConnector
ccWaypointConnector
ccWideConnector
ccpCopy
ccpCopyConfig
ccpCopyDesign
ccpCopyExactDesign
ccpDmHasRename
ccpDmRename
ccpExpand
ccpExpandConfig
ccpExpandDesign
ccpExpandExactDesign
ccpGetAutoRename
ccpRegMonitor
ccpRegTrigger
ccpRemoveTrigger
ccpRename
ccpRenameReferenceLib
ccpSetAutoRename
cdfCopyCDF
cdfCopyParam
cdfCreateBaseCellCDF
cdfCreateBaseLibCDF
cdfCreateParam
cdfCreateUserCellCDF
cdfCreateUserLibCDF
cdfDeleteCDF
cdfDeleteParam
cdfDisableScaleFactorRetentionForZero
cdfDump
cdfDumpAll
cdfEditScaleFactors
cdfEnableScaleFactorRetentionForZero
cdfFindParamByName
cdfFormatFloatString
cdfGetBaseCellCDF
cdfGetBaseLibCDF
cdfGetCellCDF
cdfGetCustomViaCDF
cdfGetInstCDF
cdfGetLibCDF
cdfGetUnitScaleFactor
cdfGetUserCellCDF
cdfGetUserLibCDF
cdfParseFloatString
cdfRefreshCDF
cdfSaveCDF
cdfSetUnitScaleFactor
cdfSyncInstParamValue
cdfUpdateCustomViaParam
cdfUpdateInstParam
cdfUpdateInstSingleParam
cdr
cdsFixedViaDefs
cdsGetInstPath
cdsGetNetlistMode
cdsGetToolsPath
cdsName
cdsNetExpr
cdsParam
cdsPlat
cdsSetNetlistMode
cdsTerm
ceiling
centerBox
changeClass
changeEnterFun
changeNextEnterFun
changeWorkingDir
charToInt
checkContextBit
ciAPRCascodeIterator
ciAPRDIDeviceGroupIterator
ciAPRDINetIterator
ciAPRXYInstSymmetricIterator
ciActiveSameCellAndSizeIterator
ciAddHierarchicalNotes
ciAddLeadingSlash
ciAddProcessRules
ciAddRuleGroup
ciAddStructArg
ciAddTrailingSlash
ciAlignPinsOnCellSide
ciAllCellViewsInHierarchy
ciAxisCreate
ciAxisDelete
ciAxisExists
ciAxisListCon
ciAxisListParams
ciAxisReplaceParams
ciBasicGetParamValue
ciBlockResistorArrayIterator
ciBuildModgenParams
ciBundleSignalsIterator
ciCPRegistrationFromLAM
ciCacheCallbackRegister
ciCacheCallbackUnregister
ciCacheCallbackUpdate
ciCacheCellName
ciCacheConstraintCellName
ciCacheConstraintLibName
ciCacheConstraintViewName
ciCacheDiscardEdits
ciCacheFind
ciCacheGet
ciCacheGetAllNetNames
ciCacheGetCellView
ciCacheGetEnabledNotifications
ciCacheIsLayout
ciCacheIsModified
ciCacheIsWritable
ciCacheLCV
ciCacheLibName
ciCacheListAxesNames
ciCacheListCon
ciCacheListConstrainedObjectNames
ciCacheListConstrainedObjects
ciCacheListTemplates
ciCacheListTypeNames
ciCacheListTypes
ciCacheMakeEditable
ciCacheMakeReadOnly
ciCacheNeedRefresh
ciCacheNotifications
ciCachePurge
ciCacheSave
ciCacheTopCellName
ciCacheTopLibName
ciCacheTopViewName
ciCacheTransfer
ciCacheTransferSelection
ciCacheViewName
ciCachep
ciCanCGBeUsed
ciCascodeSeriesCurrentMirrorIterator
ciCategoryListFinderNames
ciCheckConstraints
ciCheckDINetHierConsistency
ciClearNetSuperTypes
ciClusterBoundaryForCluster
ciCollectDeviceInfo
ciCombineInstNetsPins
ciCommonGateAndSourceIterator
ciCommonGateIterator
ciCommonSourceIterator
ciConAppendOneMember
ciConBaseName
ciConCallbackIsRegistered
ciConCreate
ciConCreateExpanded
ciConDelete
ciConDeleteAll
ciConFind
ciConGetAxisName
ciConGetCache
ciConGetComment
ciConGetCreatedTime
ciConGetMembersOfType
ciConGetName
ciConGetNote
ciConGetOwner
ciConGetPriority
ciConGetStatus
ciConGetType
ciConIsInContext
ciConIsOutOfContext
ciConIsOverridden
ciConIsWritable
ciConListMemberNames
ciConListMembers
ciConListParamNames
ciConListParams
ciConListTemplates
ciConRegisterCallback
ciConRemoveMembers
ciConResetAllParams
ciConResetParams
ciConSetAxis
ciConSetNote
ciConSetPriority
ciConSetStatus
ciConTypeHasNamedParameter
ciConUnregisterCallback
ciConUpdateCallback
ciConUpdateMemberParams
ciConUpdateMembers
ciConUpdateParams
ciConUprevCellBoundary
ciConVerify
ciConp
ciConstraintLCV
ciConstraintViewLessp
ciConstraintsForType
ciConvertNestedNetClassToNetClassHierGroup
ciConvertParamsDPLToParams
ciConvertParamsToDPL
ciConvertToConArg
ciCreateFilter
ciCreateGuardRing
ciCreateModgen
ciCreateModgenDummy
ciCreateModgenForStructure
ciCreateRoutePriorityCon
ciCreateRoutingLayerEnumString
ciCurrentPathIterator
ciDIGetRegisteredIgnoredTerminals
ciDIHierConsistencyCheck
ciDIHierPushDown
ciDIHierPushDownDIWithPaths
ciDIHierPushUp
ciDIHierPushUpDIWithPaths
ciDIRegisterIgnoredTerminals
ciDefaultParamToMatchFilter
ciDeleteClusterMembersWithinModgens
ciDeleteGuardRing
ciDeleteModgenTopologies
ciDeleteRuleGroup
ciDeleteStructArg
ciDeleteSymmetriesWithinModgens
ciDeleteUnreferencedObjects
ciDesignLCV
ciDevGroupBoxIterator
ciDeviceInfoGetRegisteredParams
ciDeviceInfoGetRegisteredTerminals
ciDeviceInfoRegisterParams
ciDeviceInfoRegisterTerminals
ciDeviceInfoRegistry
ciDeviceInfoRestoreDefaultParamNames
ciDeviceInfoRestoreDefaultTerminalNames
ciDeviceInfoTerminalsAreValid
ciDiMinMaxVPropertyCallback
ciDiPostTransferHighCurrent
ciDiPostTransferMinMaxVoltage
ciDiReplaceOrAddPropertyGroupDef
ciDiReportGenReport
ciEnableAssistant
ciEnableAutoConstraintNotes
ciEvaluateGeneratorArgs
ciExpandAndRepeatName
ciExpandIteratedDeviceInfo
ciExpandMembers
ciExpandName
ciExtractRowNumber
ciFindConsWithDuplicateMembers
ciFindDeviceArraysForDev
ciFindObjectInHier
ciFindOpenCellView
ciFindOpenCellViews
ciGUIArgsToConArgs
ciGenerateArrayChannelDesc
ciGenerateBestFitPattern
ciGenerateCascodedCurrentMirrorChannelDesc
ciGenerateCascodedCurrentMirrorPattern
ciGenerateConstraintGroup
ciGenerateCurrentMirrorChannelDesc
ciGenerateCurrentMirrorPattern
ciGenerateDiffPairChannelDesc
ciGenerateDiffPairPattern
ciGenerateLargeMfactorPattern
ciGeneratorCheckInstsNetsPinsInstTerms
ciGeneratorForInstSymmetry
ciGeneratorForNetSymmetry
ciGetAction
ciGetCPSelectedResults
ciGetCellTermDefaultNetName
ciGetCellView
ciGetCellViewForObjectPath
ciGetConnectedInsts
ciGetConstraintGroupsEnum
ciGetCustomFilterNames
ciGetDefaultNetName
ciGetDeviceBulkTermName
ciGetDeviceInfo
ciGetDeviceNames
ciGetDeviceTermName
ciGetFinder
ciGetFirstDeviceTermName
ciGetFluidGuardRingDeviceEnum
ciGetFoundryRules
ciGetGenerator
ciGetGuardRing
ciGetGuardRingMPPName
ciGetIterator
ciGetLAMComponentTypes
ciGetMappedDeviceNames
ciGetMatchParam2DList
ciGetMembersOfType
ciGetNetNames
ciGetNetSubTypes
ciGetNetSuperTypes
ciGetObjectCellView
ciGetOpenCellViews
ciGetParamMapping
ciGetParamName
ciGetParamValFromParameters
ciGetParamValue
ciGetParamValueOrDefault
ciGetParamValues
ciGetRoutingLayer
ciGetRoutingLayers
ciGetRule
ciGetRuleGroupByName
ciGetRuleGroupName
ciGetRuleGroups
ciGetStructArg
ciGetStructArgs
ciGetStructGeneratorExpressions
ciGetStructPDKMult
ciGetStructure
ciGetTechFile
ciGetTechMPPNames
ciGetTermNames
ciGetWidgetProperties
ciGuardRingForCluster
ciGuardRingForModgen
ciHasCellAnyRegTerm
ciHaveSameBulkNets
ciHaveSameParamValues
ciHierCompareConstraint
ciHierCompareConstraints
ciHierUpdateConstraints
ciHierarchicalSeriesIterator
ciHighestLevelNet
ciIgnoreDevice
ciInstGetSplitFingers
ciInstIterator
ciInstListSplitFingers
ciInstSetSplitFingers
ciInstTermIterator
ciInstsNetsPinsFromSelSet
ciIsDevice
ciIsNet
ciIsNetSuperType
ciListAllCategoryNames
ciListAllFinderNames
ciListAllGeneratorNames
ciListAllIteratorNames
ciListAllStructureNames
ciListEditors
ciListGeneratableConstraintGroups
ciListProcessRules
ciListStructGeneratorExpressions
ciListStructPDKMults
ciListStructTypes
ciListTemplateTypes
ciListTypes
ciLoadConfigXML
ciLoadConfigXMLFromString
ciLoadConstrFrom
ciLoadDotCadenceFiles
ciLoadIcon
ciLoadIcons
ciLxComparisonReport
ciMOSActiveLoadStructIterator
ciMOSCascodeIterator
ciMOSCascodedCurrentMirrorStructIterator
ciMOSCascodedCurrentMirrorStructIterator2
ciMOSCommonGateStructIterator
ciMOSCrossCoupledDifferentialPairStructIterator
ciMOSCrossCoupledQuadStructIterator
ciMOSCurrentMirrorStructIterator
ciMOSDifferentialPairStructIterator
ciMOSInverterStructIterator
ciMOSParallelStructIterator
ciMOSTransmissionGateStructIterator
ciMakeHierContext
ciMakeObjectInfo
ciMapParam
ciMapTerm
ciMatchedFingerWidth
ciMatchedParametersForCurrent_Mirror
ciMatchedParamsForInstanceSymmetry
ciMatchedParamsForSameSizeInstances
ciMemberIndexToModgenPatternSymbol
ciMergeParams
ciModgenDummyNetName
ciModgenForSameCellSizeAndBulk
ciModgenListFingerSplitCons
ciModgenMergeLayersFromArgs
ciModgenRefreshStorage
ciModgenSplitFingers
ciModgenTemplateFingerSplitPreDestroy
ciNetIterator
ciNetNames
ciNetOnTerm
ciNetPredicates
ciNetRegexs
ciNextConName
ciNextObjName
ciNextTemplateName
ciNumDevices
ciNumTermsEQ2
ciObjectIsInContext
ciObjectListCon
ciObjectPathAndName
ciOpenCellView
ciOpenPanicCellView
ciOrientationForModgen
ciPadModgenPattern
ciParallelNetResistorArrayIterator
ciParallelResistorArrayIterator
ciPinIterator
ciPlacerControlledWellGeneration
ciPrintMappedDefaultNetNames
ciPrintMappedDeviceNames
ciPrintMappedNetNames
ciPrintMappedParams
ciPrintMappedTerminals
ciPrintReport
ciPullConstraint
ciPullConstraints
ciPushConstraint
ciPushConstraints
ciRefreshCellView
ciRegTypeBindingParameter
ciRegexReplaceStructArgs
ciRegisterAction
ciRegisterAssistant
ciRegisterConstraintEditor
ciRegisterConstraintGenerator
ciRegisterCustomDeviceFilter
ciRegisterDefaultNetName
ciRegisterDevice
ciRegisterDevicesForPDKCategory
ciRegisterDynamicParamDef
ciRegisterFinder
ciRegisterIterator
ciRegisterNet
ciRegisterNetNames
ciRegisterNetPredicate
ciRegisterNetRegexs
ciRegisterNetSuperType
ciRegisterStructure
ciReinitStructTemplateDefs
ciRemoveConstrainedPinNetsFromRails
ciRemoveDuplicateMembers
ciRemoveHierarchicalNotes
ciRemoveLeadingSlash
ciRemoveProcessRules
ciRemoveSymmetricPinAlignments
ciRemoveTrailingSlash
ciReopenCellView
ciReorderAssistants
ciReplaceStructArg
ciResetDIImplementation
ciResistorArrayUpdateRowColVal
ciResolveBulkNet
ciResolveNet
ciRunFinder
ciRunFindersAndGenerators
ciRunGenerator
ciRunMatchingConstraintsGenerator
ciRunPrecondition
ciSameCellIterator
ciSaveConstraintGenerator
ciSelectedConstraints
ciSelectedTemplates
ciSeparateInstsNetsPins
ciSeriesResistorArrayIterator
ciSetCMCGSKILLCallbacks
ciSetDIPropertyGroupDefs
ciSetDefaultConstraintEditor
ciSetHaloOptions
ciSetHaloPolicy
ciSetMaxHaloGroupSize
ciSetModgenTopology
ciSetStructArgVal
ciSetStructArgs
ciSetStructGeneratorExpressions
ciSetStructPDKMult
ciSetSymmetricAxes
ciSigTypeMatchesNetType
ciSignalIterator
ciSimpleName
ciSortDeviceInfoByFingerWidth
ciSortDeviceInfoByMfactor
ciSortDeviceInfoByX
ciSortDeviceInfoByXY
ciSortDeviceInfoByY
ciSortDeviceInfoByYX
ciSortedOpenCellViews
ciTemplateAddCons
ciTemplateChangeDIProfile
ciTemplateCreate
ciTemplateCreateDI
ciTemplateCreateDefinition
ciTemplateCreateExpanded
ciTemplateDIProfileName
ciTemplateDIPropDef
ciTemplateDIPropGroupDef
ciTemplateDIPropValue
ciTemplateDefinitionExists
ciTemplateDelete
ciTemplateDeleteCons
ciTemplateFind
ciTemplateGetCache
ciTemplateGetComment
ciTemplateGetCreatedTime
ciTemplateGetDefName
ciTemplateGetName
ciTemplateGetNote
ciTemplateGetStatus
ciTemplateGetType
ciTemplateIsKindOfDI
ciTemplateListCon
ciTemplateListDIProps
ciTemplateListParamNames
ciTemplateListParams
ciTemplateResetAllParams
ciTemplateResetParams
ciTemplateSetNote
ciTemplateSetStatus
ciTemplateSortParamDefs
ciTemplateUpdateDIProps
ciTemplateUpdateParams
ciTemplatep
ciToFloat
ciTransferConstraintsInProgress
ciTypeBindingParameter
ciTypeDefBaseType
ciTypeDefVersion
ciTypeHasBindingParameter
ciTypeIsType
ciTypeIsUserDefined
ciTypeListCon
ciUnRegisterTerm
ciUnexpandDeviceInfo
ciUnexpandIteratedDeviceInfo
ciUnexpandPhysicalDeviceInfo
ciUniqueMembers
ciUnregisterAssistant
ciUnregisterConstraintEditor
ciUnregisterConstraintGenerator
ciUnregisterIterator
ciUnregisterNetSuperType
ciUpdateHierarchicalNotes
ciUpdateModgenParamsAndMembers
ciUpdateObjPropsFromDI
ciUprevEAConstrs
ciUtilsAddNTimes
ciUtilsAddQuotes
ciUtilsBuildString
ciUtilsGetArgVal
ciUtilsMakeNumberRange
ciUtilsMakeUnique
ciUtilsRemoveNils
ciUtilsRepeatNTimes
ciUtilsReplaceNils
ciVariantInfoForFingersAndFingerWidth
ciWithinConstraint
ciXYInstSymmetricIterator
ciXYNetSymmetricIterator
ciXYPinSymmetricIterator
ciXYSortInsts
ciXYSymmetricIterator
ciwAddTranslatorItem
ciwCreateMenu
ciwCreatePulldown
ciwHiExit
ciwMenuInit
ciwMenuInstall
ciwMenuLoadFile
ciwRemoveTranslatorItem
className
classOf
classp
cleCleanUpScratchCellViews
cleCreatePartition
cleCreatePartitionView
cleGetCurrentPartition
cleGetPartitions
cleGetUserTriggers
cleHasAutoSavedFile
cleHasPanicFile
cleIsAreaBasedPartition
cleIsLayerBasedPartition
cleOpenAutoSavedCellView
cleOpenPanicCellView
clePartitionAttachAreaBoundary
clePartitionGetAreaBoundaries
clePartitionGetLayers
clePartitionGetStatus
cleReInitialize
cleRefreshAssistantByCellView
cleRegUserTriggers
cleRestoreAndOpenAutoSavedFile
cleRestoreAndOpenPanicFile
cleStretchMalformedSpine
cleUnregUserTriggers
clear
clearAll
clearAllEnterFunctions
clearExitProcs
clearSubwindow
cliGetCellViewOrigCellName
cliGetCellViewOrigLibName
cliGetCellViewOrigViewName
cliIsCVType
cliReopen
cliSave
clilsDesignerMode
clilsManagerMode
clip
clipX
close
closeResults
cmdCtrlOption
cmdOption
cmdShiftOption
colorIndex
compare
compareTime
complex
complexp
compress
compression
compressionVRI
compressionVRICurves
concat
cond
conjugate
conn2Sch
conn2SchImpHdlDisplay
conn2SchStartUp
connectRules
cons
constar
converge
convolve
copy
copyDefstructDeep
cos
cosh
count
cpdCreateDeviceInfo
cpdGenerateDerivedShapes
cpdLoadDerivedShapesRules
cpdPegasusPreFormTrigger
cphChangeEditMode
cphClearCellPhysicalBinding
cphClearInstPhysicalBinding
cphClearOccurPhysicalBinding
cphClearSchCellPhysicalBinding
cphClearSchInstPhysicalBinding
cphCloseConfig
cphCloseWindow
cphCreatePhysConfig
cphDeleteCellFingerSplit
cphDeleteCellIgnoreForCheck
cphDeleteCellIgnoreForGen
cphDeleteCellMFactorSplit
cphDeleteCellParamIgnoreForCheck
cphDeleteCellParamIgnoreForGen
cphDeleteCellParamNameMapping
cphDeleteCellParamToCheck
cphDeleteCellRemoveDevice
cphDeleteCellRounding
cphDeleteCellSFactorSplit
cphDeleteCellTermIgnoreForCheck
cphDeleteCellTermIgnoreForGen
cphDeleteCellTermNameMapping
cphDeleteCellVLGen
cphDeleteCellVPLGen
cphDeleteInstFingerSplit
cphDeleteInstIgnoreForCheck
cphDeleteInstIgnoreForGen
cphDeleteInstMFactorSplit
cphDeleteInstParamIgnoreForCheck
cphDeleteInstParamIgnoreForGen
cphDeleteInstParamToCheck
cphDeleteInstRemoveDevice
cphDeleteInstRounding
cphDeleteInstSFactorSplit
cphDeleteInstTermIgnoreForCheck
cphDeleteInstTermIgnoreForGen
cphDeleteOccurFingerSplit
cphDeleteOccurIgnoreForCheck
cphDeleteOccurIgnoreForGen
cphDeleteOccurMFactorSplit
cphDeleteOccurParamIgnoreForCheck
cphDeleteOccurParamIgnoreForGen
cphDeleteOccurParamToCheck
cphDeleteOccurRemoveDevice
cphDeleteOccurRounding
cphDeleteOccurSFactorSplit
cphDeleteOccurTermIgnoreForCheck
cphDeleteOccurTermIgnoreForGen
cphFindOpenConfig
cphGetAllOpenConfigs
cphGetCell
cphGetCellFingerSplit
cphGetCellForceDescend
cphGetCellIgnoreForCheck
cphGetCellIgnoreForGen
cphGetCellMFactorSplit
cphGetCellParamIgnoreForCheck
cphGetCellParamIgnoreForGen
cphGetCellParamNameMapping
cphGetCellParamToCheck
cphGetCellPhysicalBinding
cphGetCellPhysicalCell
cphGetCellPhysicalLib
cphGetCellPhysicalView
cphGetCellRemoveDevice
cphGetCellRounding
cphGetCellSFactorSplit
cphGetCellStopList
cphGetCellTermIgnoreForCheck
cphGetCellTermIgnoreForGen
cphGetCellTermNameMapping
cphGetCellVLGen
cphGetCellVPLGen
cphGetCellVPLGenParams
cphGetCellViewBinding
cphGetCellViewList
cphGetCstList
cphGetFingerSplit
cphGetForceDescend
cphGetIgnoreForCheck
cphGetIgnoreForGen
cphGetInstFingerSplit
cphGetInstForceDescend
cphGetInstIgnoreForCheck
cphGetInstIgnoreForGen
cphGetInstMFactorSplit
cphGetInstParamIgnoreForCheck
cphGetInstParamIgnoreForGen
cphGetInstParamToCheck
cphGetInstPhysicalCell
cphGetInstPhysicalLib
cphGetInstPhysicalView
cphGetInstRemoveDevice
cphGetInstRounding
cphGetInstSFactorSplit
cphGetInstStopList
cphGetInstTermIgnoreForCheck
cphGetInstTermIgnoreForGen
cphGetInstViewBinding
cphGetInstViewList
cphGetLayoutXLConfig
cphGetLib
cphGetLibList
cphGetMFactorSplit
cphGetOccurFingerSplit
cphGetOccurForceDescend
cphGetOccurIgnoreForCheck
cphGetOccurIgnoreForGen
cphGetOccurMFactorSplit
cphGetOccurParamIgnoreForCheck
cphGetOccurParamIgnoreForGen
cphGetOccurParamToCheck
cphGetOccurPhysicalCell
cphGetOccurPhysicalLib
cphGetOccurPhysicalView
cphGetOccurRemoveDevice
cphGetOccurRounding
cphGetOccurSFactorSplit
cphGetOccurStopList
cphGetOccurTermIgnoreForCheck
cphGetOccurTermIgnoreForGen
cphGetOccurViewBinding
cphGetOccurViewList
cphGetParamIgnoreForCheck
cphGetParamIgnoreForGen
cphGetParamNameMapping
cphGetParamToCheck
cphGetPhysicalCell
cphGetPhysicalLib
cphGetPhysicalTermName
cphGetPhysicalView
cphGetRemoveDevice
cphGetRounding
cphGetSFactorSplit
cphGetSchCellPhysicalBinding
cphGetSchInstForceDescend
cphGetSchInstPhysicalBinding
cphGetSelectedSet
cphGetStopList
cphGetStopPoint
cphGetTermIgnoreForCheck
cphGetTermIgnoreForGen
cphGetTermNameMapping
cphGetTopCellName
cphGetTopCellView
cphGetTopLibName
cphGetTopViewName
cphGetView
cphGetViewBinding
cphGetViewList
cphGetWinConfig
cphGetWindowId
cphIsConfigModified
cphIsLeaf
cphIsParamIgnoredForCheck
cphIsParamIgnoredForGen
cphIsReadOnly
cphIsRemoveDevice
cphIsTermIgnoredForCheck
cphIsTermIgnoredForGen
cphIsUnderPhysConfig
cphLaunchFromLayout
cphOpenConfig
cphOpenWindow
cphReplaceCellName
cphReplaceLibName
cphReplaceViewName
cphSaveAsConfig
cphSaveConfig
cphSbAddIOPin
cphSbDefineCovObstruction
cphSbDefineIOPinLabelFlag
cphSbDefineObstruction
cphSbDefineSoftBlock
cphSbDelCovObstruction
cphSbDelIOPin
cphSbDelIOPinById
cphSbDelObstruction
cphSbDisplayAllIOPinsInfo
cphSbDisplayBoundaryInfo
cphSbDisplayCovObstructionInfo
cphSbDisplayIOPinInfo
cphSbDisplayObstruction
cphSbDisplaySoftBlockAttributes
cphSbEditIOPin
cphSbEditIOPinById
cphSbEditSoftBlockAttributes
cphSbGetAllIOPins
cphSbGetFilteredIOPins
cphSbGetIOPinId
cphSbGetIOPinName
cphSbGetSoftBlockId
cphSbGetSoftBlocks
cphSbHasCovObstruction
cphSbIsValidIOPin
cphSbLoadSoftBlocks
cphSbRemoveSoftBlock
cphSbSaveSoftBlocks
cphSbSetPolygonalBoundary
cphSbSetRectangularBoundary
cphSbSetRectangularBoundaryUsingUtil
cphSetCellFingerSplit
cphSetCellForceDescend
cphSetCellIgnoreForCheck
cphSetCellIgnoreForGen
cphSetCellMFactorSplit
cphSetCellParamIgnoreForCheck
cphSetCellParamIgnoreForGen
cphSetCellParamNameMapping
cphSetCellParamToCheck
cphSetCellPhysicalBinding
cphSetCellRemoveDevice
cphSetCellRounding
cphSetCellSFactorSplit
cphSetCellStopList
cphSetCellTermIgnoreForCheck
cphSetCellTermIgnoreForGen
cphSetCellTermNameMapping
cphSetCellVLGen
cphSetCellVPLGen
cphSetCellVPLGenParams
cphSetCellViewBinding
cphSetCellViewList
cphSetCstList
cphSetInstFingerSplit
cphSetInstForceDescend
cphSetInstIgnoreForCheck
cphSetInstIgnoreForGen
cphSetInstMFactorSplit
cphSetInstParamIgnoreForCheck
cphSetInstParamIgnoreForGen
cphSetInstParamToCheck
cphSetInstPhysicalBinding
cphSetInstRemoveDevice
cphSetInstRounding
cphSetInstSFactorSplit
cphSetInstStopList
cphSetInstStopPoint
cphSetInstTermIgnoreForCheck
cphSetInstTermIgnoreForGen
cphSetInstViewBinding
cphSetInstViewList
cphSetLibList
cphSetOccurFingerSplit
cphSetOccurForceDescend
cphSetOccurIgnoreForCheck
cphSetOccurIgnoreForGen
cphSetOccurMFactorSplit
cphSetOccurParamIgnoreForCheck
cphSetOccurParamIgnoreForGen
cphSetOccurParamToCheck
cphSetOccurPhysicalBinding
cphSetOccurRemoveDevice
cphSetOccurRounding
cphSetOccurSFactorSplit
cphSetOccurStopList
cphSetOccurStopPoint
cphSetOccurTermIgnoreForCheck
cphSetOccurTermIgnoreForGen
cphSetOccurViewBinding
cphSetOccurViewList
cphSetSchCellPhysicalBinding
cphSetSchInstForceDescend
cphSetSchInstPhysicalBinding
cphSetStopList
cphSetViewList
cphUprevDesign
cphUprevIncremental
cphUprevLibrary
cphVisitNextNode
cphVisitStart
cphVisitStop
cphVisitedInstance
cphVisitedPath
cphVisitedSwitchMaster
cphVisitedTarget
cputime
createDir
createDirHier
createFinalNetlist
createNetlist
cross
csh
cstAddToConstraintGroup
cstCreateConstraint
cstCreateConstraintGroupIn
cstCreateConstraintGroupOn
cstDeleteConstraint
cstDeleteConstraintGroup
cstFindConstraintGroupIn
cstFindConstraintGroupOn
cstFindCutClassConstraintByName
cstFindCutClassConstraintBySize
cstFindFirstConstraint
cstGet1DTableValue
cstGet2DTableValue
cstGetConstraintGroups
cstGetDefaultConstraintGroupName
cstGetFoundryCGName
cstGetFoundryConstraintGroup
cstGetTwoWidthTableValue
cstGetUnreferencedConstraints
cstIsId
cstSetDefaultConstraintGroupName
ctAddCellToCompTypeGroup
ctCreateCompTypeGroup
ctDeleteCellFromCompTypeGroup
ctDeleteCompTypeGroup
ctGetCellCompTypeGroup
ctGetCellCompTypeGroups
ctGetCompTypeCells
ctGetCompTypeGroupAttr
ctGetCompTypeNames
ctSetCompTypeGroupAttr
currentSubwindow
currentWindow
d2a
dB10
dB20
dBm
dBm50ohm
dBm50ohmAny
dagAddActionToObject
dagCreateClass
dagCreateNode
dagDeleteActionFromObject
dagDestroyNode
dagDisplayTool
dagGetCurrentObject
dagGetCurrentTool
dagLinkParentToChild
dagNumToTool
dagOpenTool
dagPopTool
dagPushTool
dagRefreshObject
dagSetActionStatus
dagSetCurrentTool
dagSetExpandedActionStatus
dagSetFont
dagUnlinkParentFromChild
dataTrigger
dataTypes
db10
db20
dbAbutIsInteractive
dbAbutIsReAbutGroup
dbAddAreaToPinGroupGuide
dbAddFigToFigGroup
dbAddFigToNet
dbAddFigToPin
dbAddFigToPinGroupGuide
dbAddFigsToPin
dbAddObjectToGroup
dbAddObjectsToMarker
dbAddPinToPinGroup
dbAddPinToPinGroupGuide
dbAddPlaceAreaBackgroundDef
dbAddPlaceAreaCompTypeSetDef
dbAddPlaceAreaRailDef
dbAddRowBackgroundDef
dbAddRowCompTypeSetDef
dbAddRowRailDef
dbAddStrapObject
dbAllCellViews
dbAreaBoundaryHasLayerPriorityOrder
dbAreaBoundaryHasValidRoutingLayers
dbAttachRowRegionToPRBoundary
dbBoundaryQuery
dbCVHasInheritedSig
dbCVHasInheritedTerm
dbCVHasNetSetProp
dbCanonicalizeAnyAngleTransform
dbCellViewAreLayerShiftsValid
dbCellViewClearLayerShifts
dbCellViewHasEquivalentConnectivityTime
dbCellViewHasLayerShifts
dbCellViewHasOpticalData
dbCellViewHasPhotonicPinFig
dbCellViewHasUnknownColorLockChanges
dbCellViewHasVirtHier
dbCellViewInitForLayerShifting
dbCellViewResetAllColorLockTypes
dbCellViewUpdateLayerShifts
dbChangeGroupType
dbCheckParamCell
dbCheckRecursion
dbClearAllActiveWireTypes
dbClearPcellCache
dbClearUnusedOccShapeColorData
dbClose
dbCloseBag
dbColorShapeQuery
dbColorShapeQuery2
dbCompressPointArray
dbCompressionPlot
dbComputeBBox
dbComputeBBoxNoNLP
dbConcatTransform
dbConvertAnyAngleTransformFromDbToMY
dbConvertArcToLine
dbConvertDonutToPolygon
dbConvertEllipseToPolygon
dbConvertLineToPath
dbConvertPathSegToPolygon
dbConvertPathToPolygon
dbConvertRectToPolygon
dbCopyCellView
dbCopyFig
dbCopyProp
dbCopyPropList
dbCopyShape
dbCopySingleProp
dbCreateArc
dbCreateAreaBoundary
dbCreateAreaPinGroupGuide
dbCreateBackgroundDef
dbCreateBackgroundDefByAttr
dbCreateBusNetDef
dbCreateBusTermDef
dbCreateCluster
dbCreateClusterBoundary
dbCreateCompTypeSetDef
dbCreateCompTypeSetDefByAttr
dbCreateConn
dbCreateConnByName
dbCreateConnByNewName
dbCreateCoverObstruction
dbCreateCurvedAreaBoundary
dbCreateCurvedPath
dbCreateCurvedPolygon
dbCreateCustomViaVariant
dbCreateDiffMaskGroup
dbCreateDonut
dbCreateDot
dbCreateEdgePinGroupGuide
dbCreateEllipse
dbCreateEnumProp
dbCreateExtParamInst
dbCreateExtParamInstByMasterName
dbCreateFigGroup
dbCreateGCellPattern
dbCreateGenViaVariant
dbCreateGroup
dbCreateGuide
dbCreateHierProp
dbCreateInPlaceCoverObstruction
dbCreateInst
dbCreateInstByMasterName
dbCreateInstTerm
dbCreateInstTermByPosition
dbCreateLabel
dbCreateLayerHalo
dbCreateLib
dbCreateLine
dbCreateMarker
dbCreateMultipleCurvedPolygons
dbCreateNamedSubNet
dbCreateNet
dbCreatePRBoundary
dbCreateParamInst
dbCreateParamInstByMasterName
dbCreateParamSimpleMosaic
dbCreateParamSimpleMosaicByMasterName
dbCreatePath
dbCreatePathSeg
dbCreatePin
dbCreatePinGroup
dbCreatePlaceArea
dbCreatePlaceBound
dbCreatePolygon
dbCreateProp
dbCreateRailDef
dbCreateRailDefByAttr
dbCreateRangeProp
dbCreateRect
dbCreateRegionBoundary
dbCreateRelatedSnapPatterns
dbCreateRoute
dbCreateRow
dbCreateRowRegion
dbCreateRowRegionSpec
dbCreateRuler
dbCreateSameMaskGroup
dbCreateSigNetExpr
dbCreateSimpleMosaic
dbCreateSnapBoundary
dbCreateStdViaVariant
dbCreateSteiner
dbCreateStrap
dbCreateStrongGroup
dbCreateTapSteiner
dbCreateTerm
dbCreateTermNetExpr
dbCreateTextDisplay
dbCreateTopology
dbCreateTrackPattern
dbCreateTrunk
dbCreateTrunkConnect
dbCreateTwig
dbCreateUniqueNamedNet
dbCreateVectorInstDef
dbCreateVia
dbCreateViaShapeArray
dbCreateWidthSpacingPattern
dbCreateWidthSpacingPatternGroup
dbCreateWidthSpacingPatternWithColor
dbCreateWidthSpacingSnapPatternDef
dbCreateXformPCell
dbDebugStats2
dbDefineProc
dbDeleteAllNet
dbDeleteAllTerminalAntennaRules
dbDeleteEmptyNet
dbDeleteFigSetGroup
dbDeleteGroupByName
dbDeleteGroupMemberFromGroup
dbDeleteHierCache
dbDeleteObject
dbDeleteObjectFromGroup
dbDeletePropByName
dbDeleteSigNetExpr
dbDeleteStrap
dbDeleteTermNetExpr
dbDeleteTerminalAntennaRuleOnLayer
dbDeleteTerminalAntennaRules
dbDeleteTopology
dbDeleteTrunk
dbDeleteTrunkConnect
dbDeleteTwig
dbDeleteWidthSpacingSnapPatternDef
dbDestroyInPlaceCoverObstruction
dbDetachPRBoundaryFromRowRegion
dbDisableCellViewCounter
dbDumpPcDefinePcell
dbDumpPcell
dbDumpPcellWithLib
dbEnableCellViewCounter
dbEnableUndo
dbEvalParamCell
dbExpandToMemNameExpr
dbExternallyConnectPins
dbFeaturePrintInfo
dbFigGroupQuery
dbFindAbutFig
dbFindAnyInstByName
dbFindBusNetDefByName
dbFindBusTermDefByName
dbFindClusterByName
dbFindFigSetGroup
dbFindFigSetGroupByName
dbFindMemInstByName
dbFindMosaicByName
dbFindNetByName
dbFindOpenBag
dbFindOpenCellView
dbFindOpenCellViewByName
dbFindPinGroupGuideByName
dbFindProp
dbFindRelatedSnapPatterns
dbFindRowByName
dbFindRowHeader
dbFindRowRegion
dbFindRowRegionSpec
dbFindSigByAlias
dbFindSigByName
dbFindTermByName
dbFindTermByPosition
dbFindVectorInstDefByName
dbFindViaHeaderByName
dbFindViaVariantByName
dbFindWidthSpacingPattern
dbFindWidthSpacingPatternGroup
dbFindWidthSpacingSnapPatternDefByName
dbFix
dbFixParamCell
dbFlattenInst
dbFlattenInst2
dbFlattenRowRegion
dbFreeze
dbFullLibPath
dbFullPath
dbGetAllTrimFillShapes
dbGetAnyInstSwitchMaster
dbGetAnyTermGroundSensitivity
dbGetAnyTermSupplySensitivity
dbGetAreaBoundaryLayerPriorityOrder
dbGetAreaBoundaryPinGroupGuide
dbGetAreaBoundaryValidRoutingLayers
dbGetAreaPinGroupGuideAreas
dbGetBackgroundDefAttr
dbGetBag
dbGetBagDdId
dbGetBagOwner
dbGetBagTimeStamp
dbGetBlockageColor
dbGetBuildInfo
dbGetCellViewActiveWireTypes
dbGetCellViewActiveWireTypesForWidthSpacingSnapPatternDef
dbGetCellViewBackgroundDef
dbGetCellViewCompTypeSetDef
dbGetCellViewCounter
dbGetCellViewDdId
dbGetCellViewEEQMaster
dbGetCellViewEquivalentConnectivityTime
dbGetCellViewFigSetGroups
dbGetCellViewInheritedSig
dbGetCellViewInheritedTerm
dbGetCellViewNetVoltageRange
dbGetCellViewPlaceArea
dbGetCellViewRailDef
dbGetCellViewRowRegionSpecs
dbGetCellViewRowRegions
dbGetCellViewSymmetry
dbGetCellViewTopologies
dbGetColorModel
dbGetColoredOccShapes
dbGetCompTypeSetDefAttr
dbGetCompTypeSetDefCompFilters
dbGetCurvedAreaBoundaryPoints
dbGetCurvedPathRealWidth
dbGetCurvedPolygonPoints
dbGetDatabaseType
dbGetDieStack
dbGetDieStacks
dbGetFigAbutName
dbGetFigAbutRefName
dbGetFigGroupByName
dbGetFigPinGroupGuide
dbGetFigSetGroupName
dbGetFileDatabaseType
dbGetFileTimeStamp
dbGetFluidShapeByName
dbGetFluidShapeName
dbGetFluidShapes
dbGetGlobalGridDefaultRepeatMode
dbGetGlobalGridOffsetReferenceType
dbGetGlobalGridRepeatMode
dbGetGroupByName
dbGetGroupsWithDef
dbGetHierCacheUsage
dbGetHierColorOverride
dbGetHierPathTransform
dbGetInPlaceCoverObstructionAbstractFileName
dbGetInPlaceCoverObstructionAbstractFilePath
dbGetInPlaceCoverObstructionAbstractViewName
dbGetInPlaceCoverObstructionBloat
dbGetInPlaceCoverObstructionBlockageAttributeValue
dbGetInPlaceCoverObstructionBlockageModel
dbGetInPlaceCoverObstructionDoughnutHalo
dbGetInPlaceCoverObstructionLayers
dbGetInPlaceCoverObstructionMaxMask
dbGetInPlaceCoverObstructionMergeDistance
dbGetInPlaceCoverObstructionMinMask
dbGetInPlaceCoverObstructionNeedsRemodeling
dbGetInPlaceCoverObstructionPinCutOut
dbGetInPlaceCoverObstructionPinRemodeling
dbGetInPlaceCoverObstructionSpacingModel
dbGetInstByName
dbGetInstNameNumInst
dbGetInstTermStraps
dbGetInstTermTwigs
dbGetInstTransform
dbGetInstanceByName
dbGetIntegrationColorModel
dbGetLibDataCompressionLevel
dbGetMarkerName
dbGetMaxHierDepth
dbGetMaxNumBit
dbGetMemName
dbGetMemNetSig
dbGetMemNetSigName
dbGetNameNumBit
dbGetNeighbor
dbGetNeighborList
dbGetNetPowerDomain
dbGetNetTerms
dbGetNetTopologies
dbGetNetVoltageRange
dbGetNetVoltageRangeSource
dbGetOpenBags
dbGetOpenCellViews
dbGetOverlaps
dbGetPRBoundaryPinGroupGuides
dbGetPatchType
dbGetPathBoundary
dbGetPathSegStyle
dbGetPatternRegionActivePattern
dbGetPatternRegionActiveWireTypes
dbGetPatternRegionAllowedPatternGroups
dbGetPatternRegionAllowedPatterns
dbGetPatternRegionCommittedPatternShiftColor
dbGetPatternRegionCommittedPatterns
dbGetPatternRegionCreateType
dbGetPatternRegionDefaultRepeatMode
dbGetPatternRegionName
dbGetPatternRegionRepeatMode
dbGetPatternRegionShiftColor
dbGetPatternRegionWidthSpacingSnapPatternDefName
dbGetPhotonicPinFigAngle
dbGetPhotonicPinFigRadius
dbGetPhotonicPinFigWidth
dbGetPinConnection
dbGetPinFigAccessDirection
dbGetPinFigName
dbGetPinFigPlacementStatus
dbGetPinGroupGuideEdgeBoundary
dbGetPinGroupGuideEdgeName
dbGetPinGroupGuideEdgeStartOffset
dbGetPinGroupGuideEdgeStopOffset
dbGetPinGroupGuideKeepoutSpacing
dbGetPinGroupGuideLayerPriorityOrder
dbGetPinGroupGuideMinPinSpacing
dbGetPinGroupGuideMinPinWidth
dbGetPinGroupGuideValidRoutingLayers
dbGetPinGroupGuides
dbGetPinGroupPlaceBoundNameAndFace
dbGetPinGroups
dbGetPinMinPinSpacing
dbGetPinMinPinWidth
dbGetPinPinGroupGuides
dbGetPlaceAreaBackgroundDef
dbGetPlaceAreaCompTypeSetDef
dbGetPlaceAreaOrient
dbGetPlaceAreaRailDef
dbGetPlaceAreaUtilization
dbGetPlaceBoundMaxHeight
dbGetPlaceBoundMinHeight
dbGetPlaceBounds
dbGetPlaceRowVersion
dbGetPlacementGrid
dbGetPowerDomainClusters
dbGetPropByName
dbGetRailDefAttr
dbGetRailDefFigType
dbGetRedoHandles
dbGetRegionBoundaryLayer
dbGetRegionBoundaryLayerType
dbGetRegionBoundaryName
dbGetRelatedSnapPatterns
dbGetRouteAuthor
dbGetRouteSubAuthor
dbGetRowBackgroundDef
dbGetRowCompTypeSetDef
dbGetRowRailDef
dbGetRowRegionAttachedToPRBoundary
dbGetRowRegionPlaceRows
dbGetRowRegionPoints
dbGetRowRegionRowRegionSpec
dbGetRowRegionSpecRowRegions
dbGetRowRegionUsesPartialRowSpec
dbGetRowRegionVersion
dbGetSameMaskDiffMaskGroups
dbGetShapeColor
dbGetShapeColorLockType
dbGetShapeEffectiveColor
dbGetShapeEffectiveColorLockType
dbGetShapeSameMaskGroups
dbGetShapeStraps
dbGetShapeTrimFillType
dbGetShapeTwigs
dbGetSigNameMemNets
dbGetSigNetExpr
dbGetSoftConnectTermConnectToLayer
dbGetSoftConnectTermPinlessLayer
dbGetStrapName
dbGetStrapObjects
dbGetStrapTopology
dbGetStrapTwig
dbGetStrongGroups
dbGetTermGroundSensitivity
dbGetTermNetExpr
dbGetTermSupplySensitivity
dbGetTerminalAntennaRuleOnLayer
dbGetTerminalAntennaRules
dbGetTopologyName
dbGetTopologyNet
dbGetTopologyObjects
dbGetTopologyPatternType
dbGetTrackPatternFirstTrackColor
dbGetTrueOverlaps
dbGetTrunkAnchor
dbGetTrunkConnectName
dbGetTrunkConnectTopology
dbGetTrunkConnectTrunks
dbGetTrunkDirection
dbGetTrunkLongOffset1
dbGetTrunkLongOffset2
dbGetTrunkLongOffsetSource
dbGetTrunkLongOffsetSource1
dbGetTrunkLongOffsetSource2
dbGetTrunkName
dbGetTrunkOrthoOffset
dbGetTrunkSide
dbGetTrunkTopology
dbGetTrunkTwigs
dbGetTwigName
dbGetTwigObject
dbGetTwigPinName
dbGetTwigTrunk
dbGetUndoHandles
dbGetVersion
dbGetViaCutLayerControl
dbGetViaLayer
dbGetViaLayer1Control
dbGetViaLayer2Control
dbGetViaLayerColorLockType
dbGetViaLayerControl
dbGetViaLayerNumColorMasks
dbGetViaStraps
dbGetViaTwigs
dbGetWidthSpacingPatternAllowedRepeatMode
dbGetWidthSpacingPatternDefaultRepeatMode
dbGetWidthSpacingPatternGroups
dbGetWidthSpacingPatterns
dbGetWidthSpacingSnapPatternDefsByLP
dbGuideQuery
dbHasAutoSavedFile
dbHasExternalConnections
dbHasFigAbutName
dbHasFigAbutRefName
dbHasInstance
dbHasMustConnections
dbHasPanicFile
dbHasPatternRegionActivePattern
dbHasPatternRegionInfo
dbHasPatternRegionNoActiveWireTypes
dbHasShape
dbHasShortedTerminals
dbHasValidHierCache
dbInPlaceCoverObstructionExists
dbInstClearLayerShifts
dbInstGetLayerShifts2
dbInstHasLayerShifts
dbInstQuery
dbInstSetLayerShifts2
dbIsAnyInstBaseNameUsed
dbIsAnyTermGroundSensitivityConsistent
dbIsAnyTermSupplySensitivityConsistent
dbIsBagId
dbIsBagReadable
dbIsBagWritable
dbIsBlockageColored
dbIsBlockageColoringAllowed
dbIsCellViewGenViaMaster
dbIsCellViewModified
dbIsCellViewNetVoltageRangeSet
dbIsCellViewPhysicalOnly
dbIsCellViewStdViaMaster
dbIsConnCurrent
dbIsCurved
dbIsFigSetGroup
dbIsFixedVia
dbIsFluidPcell
dbIsFluidShape
dbIsGenVia
dbIsGenViaHeader
dbIsGenViaVariant
dbIsId
dbIsImplicit
dbIsInRowRegion
dbIsInstTransparent
dbIsMultiTechEnabled
dbIsNetNameDescend
dbIsNetOptical
dbIsNonSKILLPcell
dbIsObjectBound
dbIsPhotonicsEnabled
dbIsRegionBoundary
dbIsRowRegion
dbIsRowRegionAttachedToPRBoundary
dbIsSameMaster
dbIsShapeColorLocked
dbIsShapeColored
dbIsShapeColoringAllowed
dbIsSigInherited
dbIsSigNameGlobal
dbIsTapSteiner
dbIsTermInherited
dbIsTermSoftConnect
dbIsTopologyPatternId
dbIsTrackPatternColorAlternating
dbIsTrackPatternColored
dbIsTrackPatternColoringAllowed
dbIsVPLGen
dbIsVRFEnabled
dbIsVRFInfraEnabled
dbIsValidSigNetExpr
dbIsValidTermNetExpr
dbIsViaColorStateLayerLocked
dbIsViaColorStateLocked
dbLayerAnd
dbLayerAndNot
dbLayerBlockageQuery
dbLayerEnclose
dbLayerHoles
dbLayerInside
dbLayerNoHoles
dbLayerOr
dbLayerOutside
dbLayerSize
dbLayerStraddle
dbLayerTile
dbLayerXor
dbListTypes
dbMakeBagCurrent
dbMakeFigSetGroup
dbMakeNet
dbMapPinGroupPins
dbMarkerQuery
dbMergeNet
dbMergeSignal
dbMergeSingleProp
dbMergeStrongGroups
dbMoveChildNet
dbMoveFig
dbMoveGroupMember
dbMovePinToNet
dbMoveShape
dbMustConnectPins
dbNetHasTopology
dbNetIsSig
dbOpenAutoSavedCellView
dbOpenBag
dbOpenCellViewByType
dbOpenHier
dbOpenPanicCellView
dbOpenParamCellView
dbOpenScratchDesign
dbParseSigNetExpr
dbParseTermNetExpr
dbPinGroupGuideHasKeepoutSpacing
dbPinGroupGuideHasLayerPriorityOrder
dbPinGroupGuideHasMinPinSpacing
dbPinGroupGuideHasMinPinWidth
dbPinGroupGuideHasValidRoutingLayers
dbPinHasMinPinSpacing
dbPinHasMinPinWidth
dbPlacementBlockageQuery
dbPointArrayAnd
dbPointArrayAndNot
dbPointArrayOr
dbPointArraySize
dbPointArrayXor
dbProduceMemName
dbProduceOverlap
dbProduceOverlapInst
dbPurge
dbPurgeBag
dbReOpenBag
dbRebuildRowRegion
dbRedoToHandle
dbRefreshBag
dbRefreshCellView
dbRefreshLibDataCompressionLevel
dbRegPostSaveAsTrigger
dbRegPostSaveTrigger
dbRegPurgeTrigger
dbRegSaveTrigger
dbRegVPLGenCreateCellName
dbRemasterAnyInst
dbRemasterInstHeader
dbRemoveFigFromFigGroup
dbRemoveLayerColorData
dbRemoveObjectsFromMarker
dbRemovePinGroupGuideEdge
dbRemovePlaceAreaBackgroundDef
dbRemovePlaceAreaCompTypeSetDef
dbRemovePlaceAreaRailDef
dbRemoveRowBackgroundDef
dbRemoveRowCompTypeSetDef
dbRemoveRowRailDef
dbRemoveStrapObject
dbRenameNet
dbReopen
dbReplaceEnumProp
dbReplaceHierProp
dbReplaceInstParamList
dbReplaceParam
dbReplaceProp
dbReplacePropList
dbReplaceRangeProp
dbReplaceSigNetExpr
dbReplaceTermNetExpr
dbResetPropList
dbRestoreAndOpenAutoSavedFile
dbRestoreAndOpenPanicFile
dbRowQuery
dbRowRegionMatchesSpec
dbRowRegionPointsCutOut
dbSave
dbSaveBag
dbSavePcellCache
dbSavePcellCacheForCV
dbSavePcellCacheForCVOnly
dbSearchCDF
dbSearchPropByName
dbSetAnyTermGroundSensitivity
dbSetAnyTermSupplySensitivity
dbSetAreaBoundaryLayerPriorityOrder
dbSetAreaBoundaryValidRoutingLayers
dbSetAutoSave
dbSetAutoSaveCallback
dbSetBeginPatch
dbSetBlockageColor
dbSetBoundaryEdge
dbSetCellViewActiveWireTypes
dbSetCellViewActiveWireTypesForWidthSpacingSnapPatternDef
dbSetCellViewEEQMaster
dbSetCellViewEquivalentConnectivityTime
dbSetCellViewNetVoltageRange
dbSetCellViewSymmetry
dbSetColorModel
dbSetCompTypeSetDefCompFilters
dbSetConnCurrent
dbSetCurvedAreaBoundaryPoints
dbSetCurvedPathRealWidth
dbSetCurvedPolygonPoints
dbSetEndPatch
dbSetFigAbutName
dbSetFigAbutRefName
dbSetFluidShape
dbSetFullPatch
dbSetGenViaParamDefault
dbSetGlobalGridDefaultRepeatMode
dbSetGlobalGridOffsetReferenceType
dbSetGlobalGridRepeatMode
dbSetHierCacheUsage
dbSetInPlaceCoverObstructionAbstractFileName
dbSetInPlaceCoverObstructionAbstractFilePath
dbSetInPlaceCoverObstructionAbstractViewName
dbSetInPlaceCoverObstructionBloat
dbSetInPlaceCoverObstructionBlockageAttributeValue
dbSetInPlaceCoverObstructionBlockageModel
dbSetInPlaceCoverObstructionDoughnutHalo
dbSetInPlaceCoverObstructionMergeDistance
dbSetInPlaceCoverObstructionNeedsRemodeling
dbSetInPlaceCoverObstructionPinCutOut
dbSetInPlaceCoverObstructionPinRemodeling
dbSetInPlaceCoverObstructionSpacingModel
dbSetInstHeaderMasterName
dbSetInstHeadersCounter
dbSetInstTransparent
dbSetIntegrationColorModel
dbSetLibDataCompressionLevel
dbSetMarkerName
dbSetNIMsgMode
dbSetNetNameDescend
dbSetNetPowerDomain
dbSetNetVoltageRange
dbSetNetVoltageRangeSource
dbSetOccShapeColor
dbSetOccShapeColorLockType
dbSetOccShapeColorLocked
dbSetPatchType
dbSetPathSegPoints
dbSetPathSegStyle
dbSetPatternRegionActivePattern
dbSetPatternRegionActiveWireTypes
dbSetPatternRegionAllowedPatternGroups
dbSetPatternRegionAllowedPatterns
dbSetPatternRegionDefaultRepeatMode
dbSetPatternRegionName
dbSetPatternRegionNoActiveWireTypes
dbSetPatternRegionRepeatMode
dbSetPatternRegionShiftColor
dbSetPatternRegionWidthSpacingSnapPatternDefName
dbSetPhotonicPinFigAngle
dbSetPhotonicPinFigRadius
dbSetPhotonicPinFigWidth
dbSetPinFigAccessDirection
dbSetPinFigName
dbSetPinFigPlacementStatus
dbSetPinGroupGuideEdge
dbSetPinGroupGuideEdgeStartOffset
dbSetPinGroupGuideEdgeStopOffset
dbSetPinGroupGuideKeepoutSpacing
dbSetPinGroupGuideLayerPriorityOrder
dbSetPinGroupGuideMinPinSpacing
dbSetPinGroupGuideMinPinWidth
dbSetPinGroupGuideValidRoutingLayers
dbSetPinMinPinSpacing
dbSetPinMinPinWidth
dbSetPlaceAreaOrient
dbSetPlaceAreaUtilization
dbSetPlaceBoundMaxHeight
dbSetPlaceBoundMinHeight
dbSetPlacementGrid
dbSetRailDefFigType
dbSetRouteAuthor
dbSetRouteSubAuthor
dbSetRowRegionPoints
dbSetRowRegionRowRegionSpec
dbSetRowRegionUsesPartialRowSpec
dbSetShapeColor
dbSetShapeColorLockType
dbSetShapeColorLocked
dbSetSoftConnectTermConnectToLayer
dbSetSoftConnectTermPinlessLayer
dbSetStrapName
dbSetStrapTwig
dbSetTermGroundSensitivity
dbSetTermMustConnectAllPins
dbSetTermMustJoin
dbSetTermSoftConnect
dbSetTermSupplySensitivity
dbSetTerminalAntennaRuleOnLayer
dbSetTerminalAntennaRules
dbSetTextDisplayNameValueVisible
dbSetTopologyName
dbSetTopologyNet
dbSetTrackPatternColorAlternating
dbSetTrackPatternFirstTrackColor
dbSetTrunkAnchor
dbSetTrunkConnectName
dbSetTrunkConnectTrunks
dbSetTrunkDirection
dbSetTrunkLongOffset1
dbSetTrunkLongOffset2
dbSetTrunkLongOffsetSource
dbSetTrunkLongOffsetSource1
dbSetTrunkLongOffsetSource2
dbSetTrunkName
dbSetTrunkOrthoOffset
dbSetTrunkSide
dbSetTwigName
dbSetTwigObject
dbSetTwigPinName
dbSetUndoHandle
dbSetViaColorInfo
dbSetViaColorStateLayerLocked
dbSetViaColorStateLocked
dbSetViaCutLayerControl
dbSetViaLayer1Control
dbSetViaLayer2Control
dbSetViaLayerColorLockType
dbSetViaLayerControl
dbSetViaParamDefault
dbSetViaShapePurpose
dbSetWidthSpacingPatternRepeatMode
dbShapeQuery
dbSoftConnectTermHasConnectToLayer
dbSoftConnectTermHasPinlessLayer
dbStartGenAnyInstToInstTerm
dbStartGenInstHeader
dbStartGenInstHeaderToAnyInst
dbStartGenLPPHeaderToShape
dbStartGenLPToShape
dbStartGenMarker
dbStartGenNet
dbStartGenNetToInstTerm
dbStartGenNetToRoute
dbStartGenRoute
dbStartGenShape
dbStartGenTerm
dbStartGenViaHeader
dbStartGenViaHeaderToVia
dbSteinerQuery
dbStopGen
dbStronglyConnectPins
dbSubAreaFromPinGroupGuide
dbSubFigFromNet
dbSubFigFromPin
dbSubFigFromPinGroupGuide
dbSubFigsFromPin
dbSubPinFromPinGroupGuide
dbTermHasMustConnectAllPins
dbTransformAccessDirection
dbTransformBBox
dbTransformCellView
dbTransformPoint
dbTransformPointList
dbUnabutGroup
dbUndefineProc
dbUndoToHandle
dbUnregPostSaveAsTrigger
dbUnregPostSaveTrigger
dbUnregPurgeTrigger
dbUnregSaveTrigger
dbUnregVPLGenCreateCellName
dbUnsetAreaBoundaryLayerPriorityOrder
dbUnsetAreaBoundaryValidRoutingLayers
dbUnsetCellViewEquivalentConnectivityTime
dbUnsetCellViewNetVoltageRange
dbUnsetCellViewPhysicalOnly
dbUnsetCompTypeSetDefCompFilters
dbUnsetLibDataCompressionLevel
dbUnsetNetVoltageRange
dbUnsetNetVoltageRangeSource
dbUnsetPhotonicPinFigAngle
dbUnsetPhotonicPinFigRadius
dbUnsetPhotonicPinFigWidth
dbUnsetPinGroupGuideKeepoutSpacing
dbUnsetPinGroupGuideLayerPriorityOrder
dbUnsetPinGroupGuideMinPinSpacing
dbUnsetPinGroupGuideMinPinWidth
dbUnsetPinGroupGuideValidRoutingLayers
dbUnsetPinMinPinSpacing
dbUnsetPinMinPinWidth
dbUnsetTermMustJoin
dbUpdatePcellCache
dbValidP
dbViaQuery
dbWeaklyConnectPins
dbWriteSkill
dbWriteSkillWithLib
dbm
dbobjectp
dc
dcmatchSummary
ddAmUsingDM
ddAutoCheckin
ddAutoCheckout
ddAutoCtlGetVars
ddAutoCtlSetVars
ddCatAddItem
ddCatClose
ddCatFindCat
ddCatGetCatMembers
ddCatGetCatName
ddCatGetCellsNotInCat
ddCatGetLibCats
ddCatIsObjInCat
ddCatOpen
ddCatOpenEx
ddCatRefresh
ddCatRemove
ddCatSave
ddCatSubItem
ddCheckin
ddCheckout
ddClearLibUnmanaged
ddCreateLib
ddDeleteLocal
ddDeleteObj
ddDumpLibList
ddGetCoManagedSet
ddGetCombineValue
ddGetDisplayValue
ddGetForcedLib
ddGetForcedLibEx
ddGetLibList
ddGetObj
ddGetObjAccess
ddGetObjAccessEx
ddGetObjChildren
ddGetObjChildrenEx
ddGetObjDMSys
ddGetObjFiles
ddGetObjFilesEx
ddGetObjGroup
ddGetObjGroupEx
ddGetObjLastModify
ddGetObjLastModifyEx
ddGetObjLib
ddGetObjName
ddGetObjOwner
ddGetObjOwnerEx
ddGetObjParent
ddGetObjReadPath
ddGetObjReadPathEx
ddGetObjSize
ddGetObjSizeEx
ddGetObjType
ddGetObjWritePath
ddGetObjWritePathEx
ddGetPathDMSys
ddGetStartup
ddGetTmpdirWarn
ddGetTriggerList
ddGetUpdatedLib
ddHiCreateCellComboField
ddHiCreateCellToolbarComboBox
ddHiCreateLibraryComboField
ddHiCreateLibraryToolbarComboBox
ddHiCreateViewComboField
ddHiCreateViewToolbarComboBox
ddHiLinkFields
ddIsHiddenCell
ddIsId
ddIsObjLibMarked
ddIsObjReadable
ddIsObjReadableEx
ddIsObjWritable
ddIsObjWritableEx
ddIsPathManageable
ddIsPathManaged
ddLibHasTmpDir
ddLibIs5X
ddLockDescribe
ddLockFree
ddLockGetStatus
ddLockPath
ddLockSet
ddLockSetEx
ddMapGetDataTypeFileName
ddMapGetDataTypeList
ddMapGetFileDataType
ddMapGetFileTool
ddMapGetFileViewType
ddMapGetToolNameDataType
ddMapGetToolNameList
ddMapGetToolNameViewType
ddMapGetViewTypeFileName
ddMapGetViewTypeList
ddMapIsFileNameKnown
ddMapIsToolLegal
ddMapIsToolNameKnown
ddMarkObjMaster
ddNeedCheckout
ddObjHasNamedObj
ddObjHasNamedObjEx
ddObjIsInMaster
ddObjIsInTmp
ddProduceObjRelNames
ddProduceObjRelNamesEx
ddRegHiddenCellsFunc
ddRegTrigger
ddReleaseObj
ddSetForcedLib
ddSetForcedLibEx
ddSetLibDmType
ddSetLibUnmanaged
ddSetTmpdirWarn
ddUnregHiddenCellsFunc
ddUnregTrigger
ddUpdateLibList
ddoAccepts
ddoPreferred
ddsAboutDFII
ddsBrowserAction
ddsCheckSessionName
ddsCheckinPreferences
ddsCheckoutPreferences
ddsCloseLibManager
ddsEditProp
ddsEndSyncWithForm
ddsFileBrowseCB
ddsGetCurrentLib
ddsGetCustomLibSelect
ddsGetLibManLCV
ddsGetLibManLogFileName
ddsGetServiceName
ddsHiCloseData
ddsHiCreateLibrary
ddsHiMakeReadOnly
ddsHiOpenCdsLibEditor
ddsHiPreferences
ddsHiRefresh
ddsHiSaveData
ddsLEWhatsNewAtStartup
ddsOnLineHelp
ddsOpenConvertToolBox
ddsOpenLibManager
ddsProgramName
ddsRefresh
ddsRegCustomLibSelect
ddsRegPostRefreshTrigger
ddsRegPreRefreshTrigger
ddsServSelect
ddsSetLibManLCV
ddsSyncWithForm
ddsUnregCustomLibSelect
ddsUpdateSyncWithForm
ddsViewDDProp
ddsWhatsNew
deAddAppCapabilities
deBack
deBeginConfigurePlugins
deCopy
deCustomizeToolbars
deDisableApp
deEditInPlace
deEnableApp
deEndConfigurePlugins
deFileNew
deFileOpen
deFindAssistant
deFindPlugin
deFindToolbar
deForward
deGetAllApplicationNames
deGetAllRootTypes
deGetAllViewTypes
deGetAppClassInfo
deGetAppInfo
deGetCellView
deGetConfigId
deGetContext
deGetEIP
deGetEditCellView
deGetEditContext
deGetEditLevel
deGetEditRootType
deGetEditViewType
deGetLowerTierApp
deGetMaxEditLevel
deGetMaxInContextLevel
deGetPlugins
deGetProbeContext
deGetProbeTrigger
deGetPushed
deGetRootType
deGetRootViewTypeList
deGetVector
deGetViewType
deHiSetDefaultApplication
deInheritEnabling
deInheritMenus
deInstallApp
deInstallPlugin
deIsEditInContext
deManageToolbar
deMapUserTypeToViewType
deMapViewTypeToUserType
deNew
deNewCellView
deOpen
deOpenCellView
dePush
deRegApp
deRegPlugin
deRegProbeTrigger
deRegUserTriggers
deRemoveAppCapabilities
deRemovePlugin
deReturn
deSetCellView
deSetConfigId
deSetContext
deSetHistoryOpenMode
deSetProbeContext
deSetWorkspace
deSwap
deToggleAssistantVisibility
deToggleAssistants
deToggleToolbars
deUnInheritEnabling
deUnInheritMenus
deUnRegApp
deUnRegProbeTrigger
deUnRegUserTriggers
deUnmanageToolbar
deViewTypeIsRegistered
debugQuit
debugStatus
declare
declareLambda
declareNLambda
declareSQNLambda
decode
defCapDepends
defCapPrefixes
defInitProc
defMathConstants
defUserInitProc
defcell
defclass
defdynamic
defgeneric
defglobalfun
definPostTranslate
definPreTranslate
define
define_syntax
definitionFile
defmacro
defmethod
defoutPostTranslate
defoutPreTranslate
defprop
defsetf
defstruct
defstructp
defun
defvar
delay
delayMeasure
delete
deleteChecks
deleteDir
deleteFile
deleteJob
deleteOpPoint
deletePoint
deleteSubckt
deleteSubwindow
deleteWaveform
densityEstimateWaveform
deoEnableTrigger
deoExitTrigger
deoGetAssistantList
deoGetBindkeys
deoMenuTrigger
deoOnApplicationChange
deoOnEvent
deoOnTabSwitch
deoPostInstallTrigger
deoRequireToolbars
deoUpdateToolbar
deriv
desVar
describe
design
destructuringBind
dft
dftbb
difference
digitalHostMode
digitalHostName
disableAllChecks
disableChecks
disableDeviceChecking
discipline
display
displayChecks
displayMode
displayNetlist
displaySubckt
dlAddArc
dlAddBox
dlAddCircle
dlAddDonut
dlAddEventObject
dlAddPath
dlAddPoint
dlAddPolygon
dlAddRasterText
dlAddSegment
dlAddSkillObject
dlAddStrokeText
dlAttachDlistToWidget
dlAttachDlistToWindow
dlClearDisplayList
dlCloseWidget
dlConfigureButton
dlDetachDlistFromWidget
dlDetachDlistFromWindow
dlDisplay
dlDlistToIcon
dlDrawArc
dlDrawBox
dlDrawCircle
dlDrawDonut
dlDrawPath
dlDrawPoint
dlDrawPolygon
dlDrawRasterText
dlDrawSegment
dlDrawStrokeText
dlEnableItem
dlFitDlistOnDraw
dlGetRasterTextWidth
dlMakeDisplayList
dlMakeDlistButton
dlMakePenTable
dlMakeStipple
dlMakeWidget
dlMapWidget
dlMoveButton
dlQueryRasterFont
dlResizeButton
dlSaveDlist
dlSetClearOnDraw
dlSetCurrentPen
dlSetDlistPosition
dlSetDlistScale
dlSetPenColor
dlSetPenFillStyle
dlSetPenFilled
dlSetPenStipple
dlSetPenTable
dlSetWidgetName
dlUnMapWidget
dmAddCellToCategory
dmCreateCellCategory
dmRemoveCellCategory
dmRemoveCellFromCategory
dmbGetCurrentLib
dmbLibBrowserFormDone
dmbOpenLibBrowser
dmbSetBrowserInteractions
dmbSyncWithCellForm
dmbSyncWithForm
dmbUpdateBrowser
dnl
do
dplp
drAddElem
drCreateEmptyWaveform
drCreateVec
drCreateWaveform
drDeleteColor
drDeleteDisplay
drDeleteLineStyle
drDeletePacket
drDeleteStipple
drDumpDrf
drFindPacket
drGetActiveDisplayDrf
drGetColor
drGetDisplay
drGetDisplayIdList
drGetDisplayName
drGetDisplayNameList
drGetElem
drGetLineStyle
drGetLineStyleIndexByName
drGetPacket
drGetPacketAlias
drGetPacketFillStyle
drGetPacketList
drGetStipple
drGetStippleIndexByName
drGetWaveformXType
drGetWaveformXVec
drGetWaveformYType
drGetWaveformYVec
drIsDataVector
drIsParamWave
drIsWaveform
drLoadDrf
drPutWaveformXVec
drPutWaveformYVec
drSetElem
drSetPacket
drType
drVectorLength
drain
drawEnterFun
drbBrowseFormCB
drdAddTarget
drdBatchCheck
drdBatchCheckLicenseAvailable
drdCheckedConstraintGroupItem
drdCheckedLayerGroupItem
drdCheckedRuleGroupItem
drdConstraintGroupHeaderClicked
drdConstraintHeaderClicked
drdConstraintItemClicked
drdEnablePixelThreshold
drdGetAllowedWidth
drdGetMinSpacing
drdGetMinSpanLengthSpacing
drdGetMinVoltageSpacing
drdIsPixelThresholdEnabled
drdLayerGroupHeaderClicked
drdLayerHeaderClicked
drdLayerItemClicked
drdListConstraintCategoryRules
drdOptionUpdateConstraint
drdOptionUpdateLayer
drdOptionsSet
drdRemoveTarget
drdRuleGroupHeaderClicked
drdRuleIDHeaderClicked
drdRuleIDItemClicked
drdRuleTypeHeaderClicked
drdRuleTypeItemClicked
drdSelectConstraintGroupItem
drdSelectLayerGroupItem
drdSelectSignOffRuleGroupItem
drdToggleSmartSnapMode
drdToggleSmartSnapModeForDiscreteSpacing
drdVerifySelSet
dreInvokeDre
drplACPRWithMask
drplEvmBpsk
drplEvmWrls
drplJitter
drplMcpValue
drplPacVolGnExpDen
drplParamSweepRFJc
drplParamSweepRFJcc
drplPssHarmThd
drplRFJc
drplRFJcc
drplRFValueAt
drplSprobeHPM
drplSprobePortSPData
drplSprobePortVSWR
drplSprobeYPM
drplSprobeZM
drplSprobeZPM
drplSwpHp
drplSwpSp
drplSwpYp
drplSwpZm
drplSwpZp
drplWrlsAcprValue
drvCheckLists
drvGetReviewInfo
drvListLayoutReviews
drvRegisterCheckLists
dtpr
dump
dutyCycle
dwindow
dwindowp
dynamic
dynamicLet
eadAddNetsToNetGroup
eadCreateDataSetFromLayCSV
eadCreateDataSetFromSchCSV
eadCreateDataSetLayCSVTemplate
eadCreateNetGroup
eadDeleteNetGroup
eadDeleteScratchLib
eadExtractParasitics
eadExtractParasiticsForDesign
eadGetLocCurrentLimit
eadGetNetsInNetGroup
eadGetTriggerDesc
eadInitializeDesign
eadJobClose
eadJobStatus
eadJobSubmit
eadLoadSetup
eadPreEMSetUserStopCVList
eadRegTrigger
eadRegisterCustomEMVariable
eadRemoveDesignParasitics
eadRemoveNetsFromNetGroup
eadRemoveParasitics
eadSetEMVariable
eadUnregTrigger
ed
edgeTriggeredEyeDiagram
edi
ediFinishStatus
edifLayerNumMap
edifinDisplay
edifinMakeRenameString
edit
edl
elecCreateDataSetCSVTemplate
elecGetCurrentData
elecGetDataSetNames
elecGetDataSetParamsPropValue
elecGetEnableEADMode
elecGetVsyncEnabled
elecMakeDefaultDatasetName
elecSetEnableEADMode
elecSetVsyncEnabled
elecTransferDataSets
elecUpdateDataSetParamsPropValue
elecVdrCreateConstraints
elecVdrCreateDeltaV
electDeleteDatasets
eliCheckOutAndLock
enableAllChecks
enableChecks
enableDeviceChecking
enableTrigger
encrypt
enterArc
enterBox
enterCircle
enterDonut
enterEllipse
enterFunNestLevel
enterLine
enterMultiRep
enterNumber
enterPath
enterPoint
enterPoints
enterPolygon
enterScreenBox
enterSegment
enterString
envCyclicIndexToString
envCyclicStringToIndex
envGetAvailableTools
envGetDefVal
envGetLoadedTools
envGetModifiedTools
envGetVal
envGetVarType
envIsToolModified
envIsVal
envLoadFile
envLoadVals
envOption
envRegLoadDumpTrigger
envRegSetTrigger
envSetToolCurrValToDefault
envSetToolDefaultToCurrVal
envSetVal
envSetVarCurrValToDefault
envSetVarDefaultToCurrVal
envStoreEnv
envUnregLoadDumpTrigger
envUnregSetTrigger
eq
equal
eqv
err
error
errset
errsetstring
eval
evalstring
evcdFile
evcdInfoFile
evenp
evmOFDM
evmQAM
evmQpsk
exists
existss
exit
exp
expandMacro
expandMacroDeep
expr
expt
eyeAperture
eyeBERLeft
eyeBERLeftApprox
eyeBERRight
eyeBERRightApprox
eyeDiagram
eyeHeightAtXY
eyeMask
eyeMaskViolationPeriodCount
eyeMeasurement
eyeWidthAtXY
fallTime
famAddValue
famCreateFamily
famEval
famGetSweepName
famGetSweepValues
famIsFamily
famMap
famValue
fboundp
fdoc
fileLength
fileSeek
fileTell
fileTimeModified
findClass
findNamespace
findSymbol
finishEnterFun
firstVal
fix
fix2
fixp
flet
flip
float
floatp
floor
fndResetDb
fnlAbortNetlist
fnlCurrentCell
fnlCurrentCellCdsName
fnlCurrentInst
fnlCurrentInstCdsName
fnlCurrentIteration
fnlCurrentModelExtName
fnlCurrentSig
fnlCurrentSigPathName
fnlGetGlobalSigNames
fnlInstCdsNameExtName
fnlPathList
fnlPrint
fnlSearchPropString
fnlSigCdsNameExtName
fnlTermCdsNameExtName
fnlTermExtName
for
forall
foralls
forcenode
foreach
foreachs
fors
fourEval
fprintf
freq
freq_jitter
frequency
fscanf
funcall
ga
gac
gac_freq
gac_gain
gainBwProd
gainMargin
gc
gcsummary
gdmAddSpecToSpecList
gdmCreateSpec
gdmCreateSpecFromDDID
gdmCreateSpecList
gdmExecute
gdmInspectSpec
gdmIsSpecId
gdmNextFromSpecList
gdmObjIsCreated
gdmRemovename
gdmResetSpecList
gdmSpecListp
gdmSpecType
gdmSpecp
gdmcancel
gdmci
gdmco
gdmdelete
gdmexport
gdmhistory
gdmsetdefver
gdmsetname
gdmstatus
gdmsubmit
gdmupdate
geAddHilightArc
geAddHilightBlockage
geAddHilightCircle
geAddHilightCurvedPath
geAddHilightCurvedPolygon
geAddHilightDistance
geAddHilightDonut
geAddHilightDot
geAddHilightEllipse
geAddHilightFig
geAddHilightLabel
geAddHilightLine
geAddHilightPath
geAddHilightPathSeg
geAddHilightPolygon
geAddHilightRectangle
geAddHilightRow
geAddHilightRuler
geAddHilightSlicedCircle
geAddHilightSlicedDonut
geAddHilightTrackPattern
geAddInstProbe
geAddNetProbe
geAddNetProbeFromTo
geAddPathProbe
geAddSelectBox
geAddSelectPoint
geAddTermProbe
geAdjustPoint
geAdvWireSelection
geAskOverwriteMode
geBackgroundCellView
geCellViewToDlist
geCenter
geChangeCellView
geChangeEditMode
geChangeHilightPacketName
geClearIgnoreProp
geClearNetNameDisplayFilter
geClearProbeNetFilter
geClosePolygon
geCompressPointArray
geComputeQueryBbox
geCoordp
geCopySelSet
geCreateBend
geCreateHilightGroup
geCreateHilightSet
geCreateMarker
geCreateMarkerByBBox
geCreateMarkerByPoints
geCreatePacket
geCreateTaper
geCreateTrl
geCreateWindowHilightSet
geCrossSection
geCrossSectionAddLayerThickness
geCrossSectionAddLayerToSkip
geCrossSectionAddLayersToMerge
geCrossSectionAddMaterialToSkip
geCrossSectionClearConfig
geCrossSectionLoadConfig
geCyclePotentialSelectNext
geCycleSelectNext
geDSAFreeze
geDeleteAllAreaViewLevel
geDeleteAllHilightSet
geDeleteAllInstViewLevel
geDeleteAllMarker
geDeleteAllProbe
geDeleteAllWindowHilightSet
geDeleteAreaViewLevel
geDeleteHilightGroup
geDeleteHilightObject
geDeleteHilightSet
geDeleteHilightSetInWindows
geDeleteInstProbe
geDeleteInstViewLevel
geDeleteNetProbe
geDeletePathProbe
geDeleteProbe
geDeleteSelSet
geDeleteStoredSelectionSet
geDeleteTermProbe
geDeselectAll
geDeselectAllFig
geDeselectAllObject
geDeselectArea
geDeselectFig
geDeselectFigNoFilter
geDeselectFigPoint
geDeselectFigs
geDeselectObject
geDeselectObjectNoFilter
geDeselectObjectPoint
geDeselectPoint
geDeselectProtected
geDeselectStoredSelectionSet
geDisableBackgroundCellView
geDiscardEdits
geDispWinEnvProps
geDrawHilightSet
geEditInPlace
geEditSelSet
geEditSingleObject
geEditToWindowPoint
geEnableBackgroundCellView
geEnableNetNameDisplay
geEnterAddInstProbe
geEnterAddNetProbe
geEnterAddTermProbe
geEnterDeleteInstProbe
geEnterDeleteNetProbe
geEnterDeleteTermProbe
geEquivWindow
geEquivWindowSet
geExplainProbe
geFindPathToCellViewInst
geGetAdjustedPath
geGetAllAreaViewLevel
geGetAllInstViewLevel
geGetAllProbe
geGetAreaViewLevel
geGetBackgroundCellView
geGetCellViewWindow
geGetCrossProbeValue
geGetCurrentHilightSet
geGetCurrentWindowHilightSet
geGetDisabledMenus
geGetEditCellView
geGetEditCellViewWindow
geGetEditRep
geGetEnablePredicate
geGetFigHilightObjectId
geGetHierMemInst
geGetHilightObjectFigId
geGetInstHier
geGetInstHierPath
geGetInstTransform
geGetInstViewLevel
geGetLockInfo
geGetMarkerDisplayText
geGetMarkerOwner
geGetMarkerReason
geGetMarkerType
geGetNetNameDisplayFilter
geGetObjectSelectedSet
geGetPotentialSelection
geGetProbeNetFilter
geGetProbeNetStopLevel
geGetProbeUserLPP
geGetScrollPercent
geGetSelProtectedObjects
geGetSelSet
geGetSelSetCount
geGetSelSetFigPoint
geGetSelectedInstancesCount
geGetSelectedSet
geGetSortedSelectByLine
geGetStoredSelectionSets
geGetTopCellViewWindow
geGetTopLevelCellView
geGetWindowBox
geGetWindowCellView
geGetWindowRep
geGetWindowSelProtectionHighlight
geGetWindowSelProtectionSelectability
geGetWindowStatus
geHasMarker
geHiCommonFindMarker
geHiDeleteAllMarker
geHiDeleteMarker
geHiDisplaySelectionForm
geHiDragFig
geHiExplainMarker
geHiFindMarker
geHiSetSelProtectionEF
geHiStoreSelectionForm
geHiUnsetSelProtectionEF
geHighlightProtected
geInsertHilightObjectsInGroup
geInstIdToFileSpec
geIsAutoStoreSelectionOn
geIsFigAllSelected
geIsFigPartiallySelected
geIsFigSelected
geIsGraphicalWindow
geIsMarkerShape
geIsNetNameDisplayActiveOnWindow
geIsNetNameDisplayEnabled
geIsObjectAllSelected
geIsObjectPartiallySelected
geIsObjectSelected
geIsPathReentrant
geIsPointInsidePolygon
geIsPolygonReentrant
geIsSelProtection
geIsValidHilightGroup
geIsValidHilightId
geIsValidHilightObject
geIsValidHilightSet
geLoadIcon
geLoadNextProbe
geLoadProbe
geMakeProbeWithColor
geMakeProbeWithLabel
geMakeProbeWithOnColor
geMakeProbeWithoutColor
geMenuForObjectsUnderPoint
geNetNameDisplayOptionForm
geNewWindow
geOpen
gePointQuery
gePointToFig
gePopHilightStack
gePopWindowHilightStack
gePrintAllProbe
geProbeP
gePush
gePushHilightStack
geQuerySelSet
geRefresh
geRefreshCellView
geRefreshCellViews
geRefreshWindow
geRefreshWorldView
geRegCrossProbeTrigger
geRegSaveAllTrigger
geResetBackgroundCellView
geResetCellView
geResetHilightSetAlphaBlendingParameters
geResetHilightSetHaloParameters
geRestoreWinView
geReturn
geReturnToLevel
geSave
geSaveAs
geSaveHier
geSaveIcon
geSaveNetNameDisplayFilter
geSaveProbe
geSaveProbeNetFilter
geSaveWinView
geScroll
geSelObjectsPartiallySelected
geSelectAll
geSelectAllFig
geSelectArea
geSelectBy2PointsLine
geSelectByLine
geSelectFig
geSelectFigNoFilter
geSelectFigPoint
geSelectFigs
geSelectNextAutoStoreSet
geSelectNextInSelSet
geSelectObject
geSelectObjectNoFilter
geSelectPoint
geSelectPreviousAutoStoreSet
geSelectPreviousInSelSet
geSelectProtected
geSelectStoredSelectionSet
geSelectToggleObject
geSelectViaPile
geSetAreaViewLevel
geSetAutoStoreSelection
geSetBackgroundCellView
geSetCrossProbeValue
geSetEnablePredicate
geSetEnterFunctionSelectionMode
geSetHilightSetAlphaBlendingParameters
geSetHilightSetHaloParameters
geSetInstViewLevel
geSetLimitedProbe
geSetMaxCreatedProbe
geSetNetNameDisplayFilter
geSetProbeDirection
geSetProbeNetFilter
geSetProbeNetStopLevel
geSetProbeUserLPP
geSetScrollPercent
geSetSelProtection
geSetSelProtectionAllObjects
geSetSelProtectionHighlightOptionForm
geSetSelProtectionHighlightOptions
geSetTCProbeDisplayStyle
geSetWindowStatus
geShareWindowHilightSet
geShift
geSingleSelectBox
geSingleSelectPoint
geStoreSelectionSet
geSubSelectBox
geSubSelectPoint
geSwitch
geSwitchInContext
geToggleAreaSelectOption
geToggleDisplayResolution
geTogglePartialSelect
geToggleWindowSelProtectionHighlight
geToggleWindowSelProtectionSelectability
geTransformUserBBox
geTransformUserPoint
geTransparencyOptions
geUnRegCrossProbeTrigger
geUnhighlightProtected
geUnsetAllSelProtection
geUnsetSelProtection
geUpdateWindowMenus
geValidateWindow
geWindowToEditPoint
geWriteCellView
geZoomToGrid
gec
geiLoadProbe
geiSaveProbe
gensym
geqp
get
getAllLoadedFiles
getApplicableMethods
getAsciiWave
getCallingFunction
getCompatContextVersion
getCurSaveContextVersion
getCurrentTime
getCurrentWindow
getData
getDependents
getDirFiles
getFnWriteProtect
getFunType
getFunctions
getGFbyClass
getGFproxy
getInstallPath
getLogin
getMaxScreenCoords
getMethodName
getMethodRole
getMethodSpec
getMethodSpecializers
getMuffleWarnings
getNativeContextVersion
getOutstring
getPrompts
getResult
getSG
getShellEnvVar
getSimRunInfo
getSkillPath
getSkillVersion
getSymbolNamespace
getTempDir
getVarWriteProtect
getVersion
getWarn
getWorkingDir
get_filename
get_pname
get_string
getc
getchar
getd
getq
getqq
gets
globalProc
globalSigAlias
globalSignal
gmax
gmin
gmsg
gmux
go
gp
gpc
gpc_freq
gpc_gain
gpeAbutGridEntries
gpeAddDummy
gpeAddDummyInEmptyCells
gpeAddDummySurround
gpeAddInstance
gpeAddMatchGroups
gpeAddStrapEntries
gpeAddTrunkChains
gpeCancelSandbox
gpeClearChannelWidthEntry
gpeClearGridEntries
gpeClearMatchGroups
gpeClearPresetGenerators
gpeClearStrapEntries
gpeClearTopo
gpeClearTrunkChains
gpeCopyColAbutment
gpeCopyRowAbutment
gpeCreateAbutEntries
gpeCreateAbutType
gpeCreateAlignment
gpeCreateAlignmentAndSpacing
gpeCreateChannelWidthEntry
gpeCreateDummyConfig
gpeCreateDummyConfigNet
gpeCreateDummyConfigParam
gpeCreateGridEntry
gpeCreateInstTermEntries
gpeCreateMapEntry
gpeCreateMatchGroupEntry
gpeCreateSandbox
gpeCreateStrapEntries
gpeCreateTrunkChain
gpeCreateTrunkEntries
gpeCreateTwigEntries
gpeDeleteDummyEntries
gpeDeleteSandbox
gpeEditSandbox
gpeExtractReuseTemplate
gpeExtractReuseTemplatesFromLCV
gpeExtractTemplateFromMG
gpeFindArrayPatternDiffs
gpeFinishSandbox
gpeGetAbut
gpeGetAbutTypeList
gpeGetAbutTypeName
gpeGetChannelWidthEntry
gpeGetConstraints
gpeGetDefaultAbutType
gpeGetFigGroup
gpeGetGrid
gpeGetGridColCount
gpeGetGridEntries
gpeGetGridEntry
gpeGetGridRowCount
gpeGetGridSelection
gpeGetGridValue
gpeGetMap
gpeGetMapEntry
gpeGetSelection
gpeGetStrapEntries
gpeGetTrunkChains
gpeGetTwigEntries
gpeInsertEmptyColumns
gpeInsertEmptyRows
gpeIsPresetGenDisplayable
gpeIsRegisteredPresetGen
gpeIsSandboxSync
gpeIsValidAbutType
gpeLoadReuseTemplate
gpeMove
gpePlaceGridEntries
gpePresetReorientResistor
gpeRegisterPresetGen
gpeRemoveEmptyRowsAndColumns
gpeRemoveInstance
gpeRunPresetGen
gpeSboxp
gpeSelect
gpeSetAbut
gpeSetAbutEntries
gpeSetChannelWidthEntry
gpeSetGrid
gpeSetGridEntry
gpeSetGridText
gpeSetGridValue
gpeSetMap
gpeSetMapEntry
gpeSetMergeLayer
gpeSetOrientText
gpeSetRouter
gpeSetSize
gpeStacksAreCompressed
gpeStacksUncompress
gpeStartSandbox
gpeSyncSandbox
gpeUnAbutGridEntries
gpeUnSyncSandbox
gpeUnregisterPresetGen
gpeUpdateInstanceFromSchematic
graphicsOff
graphicsOn
greaterp
groupDelay
gt
gtc
gwc
hardCopy
hardCopyOptions
harmonic
harmonicFreq
harmonicFreqList
harmonicList
hdbAddConfigToBag
hdbBind
hdbBindBit
hdbBitHasRules
hdbClose
hdbCloseConfigsInBag
hdbConfigHasOccRules
hdbCreateConfigBag
hdbCreatePathVector
hdbCreatePathVectorStack
hdbDestroyPathVector
hdbExplainBinding
hdbExplainSignature
hdbExplainStop
hdbGetCellName
hdbGetLibName
hdbGetPathStackStr
hdbGetPathStr
hdbGetPathVectorStackTop
hdbGetTopCellName
hdbGetTopLibName
hdbGetTopViewName
hdbGetViewName
hdbHasIterInstBitRules
hdbIsAtStopPoint
hdbIsConfig
hdbIsIterInst
hdbIsOpenConfig
hdbIterInstHasBitRules
hdbOpen
hdbPopCell
hdbPopPathVect
hdbPushBitCell
hdbPushCell
hdbPushPathVect
hdbReOpenNewConfig
hdbSave
hdbSaveACopy
hdbSaveAs
hdbSetDefaultLibListString
hdbSetDefaultStopListString
hdbSetDefaultViewListString
hdbSetObjBindRule
hdbSetTopCellViewName
hdlGenerateTextDatabase
hdlPkgCreateEnvSetupFile
hdlPkgExportXrunArgs
heHiEditConfig
heHiSetInstBinding
heHiShowViewsFound
heHiUpdate
hedRegUICustomFunc
help
hiAbout
hiAbsolutePan
hiAddCyclicChoice
hiAddExtraRepeatCommand
hiAddField
hiAddFields
hiAddFixedMenu
hiAddIconOverrides
hiAddItemToLayout
hiAddMenuItem
hiAddNonRepeatPrefix
hiAddTextWordDelimiter
hiAddToolbarItem
hiAddToolbarItems
hiAdvanceProgressBarOneStep
hiAppendInputCmd
hiApplyWinConfig
hiBindKeyModifiers
hiBoxCenter
hiCancelProgressBox
hiChangeBannerLabel
hiChangeFormCallback
hiChangeFormTitle
hiCheckAbort
hiClearClipboard
hiClearCurrentTextSelection
hiCloseWindow
hiCollapseTreeItem
hiConfigureBindKeys
hiCreate2DMenu
hiCreateAction
hiCreateAppForm
hiCreateBBoxField
hiCreateBooleanButton
hiCreateButton
hiCreateButtonBoxField
hiCreateColorArray
hiCreateComboField
hiCreateCyclicField
hiCreateDisclosureButton
hiCreateDisclosureTriangle
hiCreateDockWindow
hiCreateFileSelectorField
hiCreateFloatField
hiCreateFloatSpinBox
hiCreateForm
hiCreateFormButton
hiCreateFormLabel
hiCreateFormLayout
hiCreateFrameField
hiCreateGridLayout
hiCreateHorizontalBoxLayout
hiCreateHorizontalFixedMenu
hiCreateHypertextField
hiCreateIntField
hiCreateLabel
hiCreateLayerCyclicField
hiCreateLayoutForm
hiCreateListBoxField
hiCreateListField
hiCreateMLTextField
hiCreateMenu
hiCreateMenuItem
hiCreateOptionsForm
hiCreateOutputStringField
hiCreatePointField
hiCreatePointListField
hiCreatePulldownMenu
hiCreateRadioField
hiCreateReportField
hiCreateScaleField
hiCreateScrollRegion
hiCreateSeparatorField
hiCreateSeparatorMenuItem
hiCreateSimpleHypertextField
hiCreateSimpleMenu
hiCreateSliderMenuItem
hiCreateSpinBox
hiCreateStackedLayout
hiCreateStringField
hiCreateTabField
hiCreateToggleField
hiCreateToolbar
hiCreateToolbarComboBox
hiCreateToolbarSeparator
hiCreateToolbarTypein
hiCreateTree
hiCreateTreeItem
hiCreateTreeTable
hiCreateTypeinMenuItem
hiCreateVerticalBoxLayout
hiCreateVerticalFixedMenu
hiCreateWindow
hiCreateWorldView
hiDBoxCancel
hiDBoxOK
hiDeiconifyWindow
hiDeleteBannerLabel
hiDeleteBannerMenu
hiDeleteBannerMenus
hiDeleteField
hiDeleteFields
hiDeleteForm
hiDeleteItemFromLayout
hiDeleteMenu
hiDeleteMenuItem
hiDeleteToolbar
hiDeleteToolbarBreak
hiDeleteToolbarItem
hiDeleteToolbarItems
hiDeltaPan
hiDisableAsstBindKeyPrefix
hiDisableMenuItem
hiDisableTailViewfile
hiDisplayAppDBox
hiDisplayBlockingDBox
hiDisplayColorDialog
hiDisplayFileDialog
hiDisplayFixedMenu
hiDisplayForm
hiDisplayListBox
hiDisplayMenu
hiDisplayModalDBox
hiDisplayModelessDBox
hiDisplayNonBlockingDBox
hiDisplayProgressBox
hiDisplaySaveForRestoreDialog
hiDisplayUserDBox
hiDisplayWindow
hiDisplayWindowMenu
hiDockWindow
hiDynamicPanAbsolute
hiDynamicPanGrabbing
hiDynamicPanInteractive
hiDynamicPanRelative
hiEditPropList
hiEditfile
hiEnableAsstBindKeyPrefix
hiEnableBlink
hiEnableMenuItem
hiEnableTailViewfile
hiEncap
hiEndLog
hiEnqueueCmd
hiEscapeHTMLTags
hiEscapeStringChars
hiExpandTreeItem
hiExportImage
hiExportImageDialog
hiFileDialogDone
hiFileDialogSelection
hiFileDialogSetSelection
hiFixedMenuDown
hiFlush
hiFlushCIW
hiFlushInfo
hiFlushLogFile
hiFocusToCIW
hiFocusToCursor
hiFocusToEncap
hiFocusToToolbarItem
hiFormApply
hiFormCancel
hiFormClose
hiFormDefaults
hiFormDone
hiFormFinish
hiFormList
hiFormUnmap
hiGenTextIndex
hiGenerateThumbnails
hiGetAbsWindowScreenBBox
hiGetActiveTabWindow
hiGetAnyFile
hiGetAppType
hiGetAttention
hiGetBBoxResource
hiGetBannerLabels
hiGetBannerMenus
hiGetBannerPoint
hiGetBeepVolume
hiGetBindKey
hiGetBindKeyInheritAlias
hiGetBindKeyInheritRoot
hiGetBindKeyPrefixList
hiGetBindKeys
hiGetButtonAreaHeight
hiGetCIWindow
hiGetChoiceStrings
hiGetClipboard
hiGetCommandPoint
hiGetCurrentCmd
hiGetCurrentEnterFunPoints
hiGetCurrentField
hiGetCurrentForm
hiGetCurrentIndex
hiGetCurrentTextSelection
hiGetCurrentTextSelectionLoc
hiGetCurrentWindow
hiGetCursor
hiGetCursorByName
hiGetCursorName
hiGetCyclicValueString
hiGetDBoxDefaultLocation
hiGetDbuPoint
hiGetDefaultThumbnail
hiGetDefaultThumbnailResolution
hiGetDefaultWidgetSpacing
hiGetDisabledAsstBindKeyPrefixes
hiGetDisplayName
hiGetDrawThruDelta
hiGetEFDrawThruDelta
hiGetEFunCursor
hiGetEncapSkillCmd
hiGetExistingDirectory
hiGetExistingFile
hiGetExistingFiles
hiGetExtraRepeatCommands
hiGetFieldAttachments
hiGetFieldInfo
hiGetFieldMinSize
hiGetFieldOverlaps
hiGetFieldScope
hiGetFont
hiGetFontInfo
hiGetFormLocation
hiGetFormSize
hiGetGeometryResource
hiGetGridLayoutItemLocation
hiGetHelp
hiGetIconName
hiGetIconOverrides
hiGetInsertionPosition
hiGetItemOfLayout
hiGetKeyboardFocusField
hiGetLayerCyclicValue
hiGetLayoutChildLayouts
hiGetLayoutFields
hiGetLayoutFrame
hiGetLayoutItemIndex
hiGetLayoutItems
hiGetLayoutMargins
hiGetLayoutType
hiGetListBoxFieldFit
hiGetListBoxValue
hiGetLogFileName
hiGetMagnifierSize
hiGetMaxScreenCoords
hiGetMenuItems
hiGetMouseMoveSampleRate
hiGetMouseStopDetectTime
hiGetMultiClickTime
hiGetNonRepeatPrefixes
hiGetNumMenus
hiGetNumVisibleItems
hiGetPoint
hiGetProgress
hiGetProgressBarCurrentStep
hiGetProgressBarTotalSteps
hiGetProgressTotalSteps
hiGetRadioValueString
hiGetRepeatCommand
hiGetScreenPoint
hiGetScreenSize
hiGetScrollBarInfo
hiGetSessionWindow
hiGetSharedIcon
hiGetStackedLayoutCurrentIndex
hiGetStringResource
hiGetStrokeBBox
hiGetStrokeFirstPt
hiGetStrokeLastPt
hiGetTextCharAtLoc
hiGetTextClass
hiGetTextDispLoc
hiGetTextFieldFit
hiGetTextIndexLoc
hiGetTextLineColumn
hiGetTextSelByLoc
hiGetTextSelection
hiGetTextSourceLength
hiGetTextWidth
hiGetTextWordDelimiter
hiGetThumbnailFilename
hiGetToolbarObjName
hiGetTopListItem
hiGetTree
hiGetTreeItemDescription
hiGetTreeItemIcons
hiGetTreeItemParent
hiGetTreeItems
hiGetTreeParent
hiGetUndoLimit
hiGetUserAbort
hiGetViewBBox
hiGetWMOffsets
hiGetWidgetType
hiGetWinConfig
hiGetWinConfigInfo
hiGetWinObjName
hiGetWindowDisplayState
hiGetWindowFixedMenu
hiGetWindowIconifyState
hiGetWindowList
hiGetWindowMenu
hiGetWindowName
hiGetWindowState
hiGetWindowToolbars
hiGetXFontName
hiGoToIndex
hiGoToLine
hiGraphicMode
hiHasToolbarBreak
hiHelp
hiHideProgressBar
hiHideToolbar
hiHighlightField
hiHypertextReadin
hiHypertextReplace
hiHypertextScroll
hiIconifyWindow
hiIgnoreProp
hiInEnterFun
hiInFormApply
hiInheritBindKey
hiInsertBannerMenu
hiInsertBlankCIWOutputPage
hiInsertItemToLayout
hiInsertMenuItem
hiInsertToolbar
hiInsertToolbarBreak
hiInsertToolbarItem
hiInsertToolbarItems
hiInstantiateForm
hiIs2DMenu
hiIsBlinkEnabled
hiIsExtraRepeatCommand
hiIsForm
hiIsFormDisplayed
hiIsIcon
hiIsInFieldCancel
hiIsInReplay
hiIsInstantiated
hiIsMagnifierAnchored
hiIsMagnifierOpened
hiIsMenu
hiIsMenuItemEnabled
hiIsMenuSlotFilled
hiIsProgressBoxCancelled
hiIsScrollRegion
hiIsWidgetType
hiIsWindowSpecifier
hiItemInsertTree
hiItemRemoveTree
hiLaunchBrowser
hiLayerDispMainForm
hiLayerMatchCyclicStr
hiLayerStringToLPP
hiLayoutUTp
hiListBoxCancel
hiListBoxDone
hiListFocusableToolbarItems
hiListView
hiLoadIconData
hiLoadIconFile
hiLoadImageFile
hiLogDragEvents
hiLookupHRFtag
hiLowerTab
hiLowerWindow
hiMakeLPChoiceList
hiMapWindow
hiMarkNestable
hiMarkNonNestable
hiMatchColor
hiMatchColorByName
hiModalDBoxHelp
hiModelessDBoxHelp
hiMoveField
hiMoveFixedMenu
hiMoveInsBarToEnd
hiMoveToFormField
hiMoveWindow
hiNextWinView
hiObShowTag
hiOffsetField
hiOffsetFields
hiOpenWindow
hiPan
hiPickWindow
hiPlaceToolbar
hiPlaceToolbarBreak
hiPrevWinView
hiPrintBindKeyUsage
hiPrintToLogFile
hiQueryFont
hiQuit
hiRaiseTab
hiRaiseWindow
hiReadWinConfig
hiReattachField
hiReattachToolbar
hiRedo
hiRedraw
hiRefreshTextWindow
hiRegCloseProc
hiRegCurWindowTrigger
hiRegSetBindKeyProc
hiRegTimer
hiRegZoomPanProc
hiRegisterBindKeyPrefix
hiRemoveExtraRepeatCommand
hiRemoveFixedMenu
hiRemoveIconOverrides
hiRemoveNonRepeatPrefix
hiRemovePromptLine
hiRemoveTextWordDelimiter
hiRepeat
hiReplaceAllBannerMenus
hiReplaceTextWordDelimiter
hiReplayFile
hiReportDeselectAllItems
hiReportDeselectItem
hiReportDeselectItems
hiReportGetSelectedItems
hiReportSelectAllItems
hiReportSelectItem
hiReportSelectItems
hiResetAbort
hiResetProgressBox
hiResizeField
hiResizeMagnifier
hiResizeWindow
hiRestoreView
hiSaveAsViewfile
hiSaveForRestore
hiSaveIconData
hiSaveView
hiSaveViewfile
hiSaveWinConfig
hiScaleBox
hiScaleMagnifier
hiScrollWindowBottom
hiScrollWindowDown
hiScrollWindowLeft
hiScrollWindowRight
hiScrollWindowToCurrentIndex
hiScrollWindowToIndex
hiScrollWindowToName
hiScrollWindowTop
hiScrollWindowUp
hiSelectTextByLoc
hiSetAbort
hiSetActionChecked
hiSetBeepVolume
hiSetBindKey
hiSetBindKeys
hiSetButtonIcon
hiSetButtonLabel
hiSetCallbackStatus
hiSetClipboard
hiSetCurrentField
hiSetCurrentForm
hiSetCurrentIndex
hiSetCurrentTextSelectionLoc
hiSetCurrentWindow
hiSetCursor
hiSetDBoxDefaultLocation
hiSetDisabledIcon
hiSetDrawThruDelta
hiSetEFDrawThruDelta
hiSetEFunCursor
hiSetEncapHistory
hiSetEncapPrompt
hiSetEncapSkillCmd
hiSetFieldEditable
hiSetFieldEnabled
hiSetFieldMinSize
hiSetFilter
hiSetFilterOptions
hiSetFont
hiSetFormBlock
hiSetFormButtonEnabled
hiSetFormHighlights
hiSetFormMinMaxSize
hiSetFormName
hiSetFormPosition
hiSetFormSize
hiSetFormToDefaults
hiSetIconName
hiSetInsertionPosition
hiSetKeyboardFocusField
hiSetLayerCyclicValue
hiSetLayoutFrameTitle
hiSetLayoutMargins
hiSetListItemCenter
hiSetListItemVisible
hiSetMenuItemCallback
hiSetMenuItemStatusTip
hiSetMenuItemText
hiSetMouseMoveSampleRate
hiSetMouseStopDetectTime
hiSetMultiClickTime
hiSetProgress
hiSetProgressAndText
hiSetProgressBannerText
hiSetProgressBar
hiSetProgressButtonText
hiSetProgressLabel
hiSetProgressText
hiSetProgressTotalSteps
hiSetScrollBarValue
hiSetSessionFocus
hiSetShadowMode
hiSetSplashBackground
hiSetSplashDefaultBackground
hiSetSplashFamily
hiSetSplashIcon
hiSetSplashLicense
hiSetSplashProduct
hiSetStackedLayoutCurrentIndex
hiSetTabWindowIcon
hiSetTabWindowTip
hiSetTabWindowTitle
hiSetTextClass
hiSetTextHighlightColor
hiSetTextSelectAll
hiSetTextSelection
hiSetToolbarObjName
hiSetTopListItem
hiSetTreeItemDescription
hiSetTreeItemIcons
hiSetTypeinMenuItemCompleterList
hiSetUndoLimit
hiSetUserPreferences
hiSetViewfile
hiSetWinObjName
hiSetWinStyle
hiSetWindowAtts
hiSetWindowDefaultPrompt
hiSetWindowFocus
hiSetWindowIcon
hiSetWindowMenu
hiSetWindowName
hiShowBindKeys
hiShowBindKeysByAppType
hiShowBindKeysByWindow
hiShowFieldBorders
hiShowListBox
hiShowProgressBar
hiShowToolbar
hiSleep
hiStartGenTextIndex
hiStartLog
hiStoreFormLocation
hiStringToIcon
hiStroke
hiSwapTreeItemSelectionIcons
hiSwitchWindowType
hiSync
hiSynchronize
hiTextDisplayString
hiTextWidth
hiToggleAnchorMagnifier
hiToggleEnterForm
hiToggleMagnifier
hiToggleMagnifierResolution
hiTreeAppendItem
hiTreeAppendItems
hiTreePrependItem
hiTreePrependItems
hiTreeRemoveAllItems
hiTreeRemoveItem
hiTreeRemoveItems
hiTreeTableDeselectAllItems
hiTreeTableDeselectItem
hiTreeTableDeselectItems
hiTreeTableGetExpandedItemCount
hiTreeTableGetExpandedItems
hiTreeTableGetItemCount
hiTreeTableGetItems
hiTreeTableGetSelectedItemCount
hiTreeTableGetSelectedItems
hiTreeTableSelectAllItems
hiTreeTableSelectItem
hiTreeTableSelectItems
hiUndo
hiUndockWindow
hiUnmapWindow
hiUnregCloseProc
hiUnregCurWindowTrigger
hiUnregZoomPanProc
hiUnselectText
hiUnselectTextAll
hiUnselectTextByLoc
hiUnselectTextClass
hiUpdate
hiUpdateFormBlock
hiUpdateMagOptions
hiUpdateTextSelectionColors
hiUseMagnifierResolution
hiUsingMagnifierResolution
hiVectorPan
hiViewTextFile
hiViewfile
hiWinConfigModified
hiWindowSaveImage
hiWorldViewFit
hiWorldViewRedraw
hiWorldViewZoomIn
hiWorldViewZoomOut
hiZoomAbsoluteScale
hiZoomExpandAtMouse
hiZoomExpandAtPoint
hiZoomIn
hiZoomInAtMouse
hiZoomInMagnifier
hiZoomOut
hiZoomOutAtMouse
hiZoomOutMagnifier
hiZoomRelativeScale
hiZoomWindowAtMouse
hiZoomWindowAtPoint
histo
histogram2D
history
hlcheck
hnlAbortNetlist
hnlAddExtraParameters
hnlCDLPrintBJTElement
hnlCDLPrintBSIM3SOIElement
hnlCDLPrintCapElement
hnlCDLPrintCapacitorElement
hnlCDLPrintCds_Thru
hnlCDLPrintDiodeElement
hnlCDLPrintGeneralElement
hnlCDLPrintICIsrcElement
hnlCDLPrintICVsrcElement
hnlCDLPrintInductorElement
hnlCDLPrintInstPropVal
hnlCDLPrintIsrcElement
hnlCDLPrintJfetElement
hnlCDLPrintMultiCNPNElement
hnlCDLPrintMultiCPNPElement
hnlCDLPrintMultiENPNElement
hnlCDLPrintMultiEPNPElement
hnlCDLPrintNMOSfetElement
hnlCDLPrintNPNElement
hnlCDLPrintPMOSfetElement
hnlCDLPrintPNPElement
hnlCDLPrintResElement
hnlCDLPrintResistorElement
hnlCDLPrintSchottkyTranElement
hnlCDLPrintTlineElement
hnlCDLPrintVCIsrcElement
hnlCDLPrintVCVsrcElement
hnlCDLPrintVsrcElement
hnlCatIncrementalNetlistFiles
hnlCellExtracted
hnlCellInAllCells
hnlCloseCellFiles
hnlCloseMasterList
hnlCompletePrint
hnlDeRegPostNetlistTrigger
hnlDeRegPreNetlistTrigger
hnlDoInstBased
hnlDoNetBased
hnlEMHGetDigitaGlobalNets
hnlEMHGetDigitalNetlistFileName
hnlEMHSetVerbosityLevel
hnlFindAllCells
hnlFindAllInstInCell
hnlGenIncludeFile
hnlGetCellHdbProps
hnlGetGlobalModelMappedName
hnlGetGlobalNetMappedName
hnlGetInstanceCount
hnlGetMappedInstNames
hnlGetMappedModelNames
hnlGetMappedNames
hnlGetMappedNetNames
hnlGetMasterCells
hnlGetPrintLinePrefix
hnlGetPropVal
hnlGetRoundProp
hnlGetScaleCapacitance
hnlGetScaleMarginalDelay
hnlGetScaleTimeUnit
hnlGetSimulator
hnlGetSourceFile
hnlGetSourceFileModels
hnlGetTermByName
hnlGetTermNameOfSig
hnlHspiceInstPropVal
hnlHspicePrintInstPropEqVal
hnlHspicePrintInstPropVal
hnlHspicePrintMOSfetModel
hnlHspicePrintNMOSfetElement
hnlIfNoProcedure
hnlIgnoreTerm
hnlInitMap
hnlInitPrint
hnlIsAPatchCord
hnlIsAStoppingCell
hnlIsCellNetlistable
hnlIsCurrentInstStopping
hnlMakeNetlistFileName
hnlMapCellModuleName
hnlMapCellName
hnlMapInstName
hnlMapModelName
hnlMapName
hnlMapNetName
hnlMapTermName
hnlMultipleCells
hnlNameOfSignal
hnlNetNameOnTerm
hnlNetNameOnTermName
hnlNmpSetNameSpaces
hnlOpenTopCell
hnlPcellIsParamOverridden
hnlPostNetlistTriggerList
hnlPreNetlistTriggerList
hnlPrintDevices
hnlPrintMessage
hnlPrintNetlist
hnlPrintSignal
hnlPrintString
hnlRegPostNetlistTrigger
hnlRegPreNetlistTrigger
hnlRunNetlister
hnlRunPinChecker
hnlScaleCapacitance
hnlScaleMarginalDelay
hnlScaleTimeUnit
hnlSetCellFiles
hnlSetDef
hnlSetMappingType
hnlSetPrintLinePrefix
hnlSetPseudoTermDir
hnlSetVars
hnlSortTerms
hnlSortTermsToNets
hnlStartNetlist
hnlStopNetlist
hnlStringToList
hnlVerilogPrintCmos
hnlVerilogPrintNmosPmos
hnlWriteBlockControlFile
hnlWriteMap
hnllsCVInUserStopCVList
hostMode
hostName
hsmDeselect
hsmGetSelectedSet
hsmSelect
i
iagCreateMenuItem
iagGenAbstract
ic
iccIsConnected
iccSendCommand
iccSendSkillCommand
iclicCheckOutAndLock
if
ifreq
ih
iim
iinteg
ilAddTopLevelErrorHandler
ilArgMatchesSpecializer
ilDebugCountLevels
ilEquivalentSpecializers
ilGenerateSpecializer
ilGetGFbyClass
ilGetIdeSessionWindow
ilGetTCovFiles
ilMergeTCovData
ilRemoveMethod
ilRemoveTopLevelErrorHandler
ilSlotBoundp
ilSpecMoreSpecificp
ilToolBox
ilgAddRecentFiles
ilgAppendText
ilgCopy
ilgCut
ilgFindIdent
ilgFindParenthesis
ilgFoldLine
ilgGetCursorLocation
ilgGetEditLock
ilgGetHighlight
ilgGetSelectedLocation
ilgGetText
ilgInvokeIDE
ilgLastDir
ilgPaste
ilgPositionInComment
ilgRegisterSelectionCB
ilgResetErrorMarker
ilgResetHighlight
ilgResetWarningMarker
ilgRunSKILLIDE
ilgScrollToLocation
ilgSearchText
ilgSelectText
ilgSetColor
ilgSetCursorLocation
ilgSetEditLock
ilgSetErrorMarker
ilgSetHighlight
ilgSetWarningMarker
ilgUnfoldLine
ilgUnregisterSelectionCB
im
imag
impHdlDisplay
importSkillVar
importSymbol
inNext
inScheme
inSkill
inStepOut
include
includeFile
index
infile
info
initializeInstance
inl
inportp
installDebugger
instring
int
intToChar
integ
integerp
intersect
ip
ip3Plot
ipcActivateBatch
ipcActivateMessages
ipcBatchProcess
ipcBeginProcess
ipcCloseProcess
ipcContProcess
ipcGetExitStatus
ipcGetPid
ipcGetPriority
ipcIsActiveProcess
ipcIsAliveProcess
ipcKillAllProcesses
ipcKillProcess
ipcReadProcess
ipcSetPriority
ipcSignalProcess
ipcSkillProcess
ipcSleep
ipcSleepMilli
ipcSoftInterrupt
ipcStopProcess
ipcWait
ipcWaitForProcess
ipcWriteProcess
ipn
ipnVRI
ipnVRICurves
iqCreateDummyCell
ir
isBBox
isCallable
isClass
isContextLoaded
isDir
isExecutable
isFile
isFileEncrypted
isFileName
isGeneric
isInfinity
isLargeFile
isLink
isLocation
isMacro
isNaN
isPortAtEOF
isReadable
isVarImported
isWritable
iseCloseSchWindow
iseCloseSimWindow
iseCommToSimulator
iseCompleteInteractive
iseEnterNodeNamesList
iseExitSimulator
iseGetExtName
iseGetInputFromEncapWindow
iseGetMappedProbeList
iseGetProbeList
iseInitSchematicWindow
iseInitSimWindow
iseInterruptSimulator
iseNetExtNameCdsName
iseOpenWindows
isePrintName
isePrintNameCB
isePrintSimulatorCommand
iseReleaseNodeFrom
iseSearchForASchWindow
iseSendOutputToEncapHistory
iseSetEncapBindKeys
iseSetNodeTo
iseSimulate
iseStartInteractive
iseStartSimulator
iseUpdateNetlist
iseUpdateStimulus
itime
ivCallProc
ivCompilingFor
ivConcICe
ivCreatePCells
ivDRC
ivERC
ivExtract
ivGetCellView
ivLVS
ivVerify
kf
killJob
kurtosis
labels
lambda
last
lastVal
lbuiGetCheckedOutLicenses
lbuiPrintLicenseUseReport
lceAddSimpleStopLayers
lceClearLogicalConn
lceDestroyVoidShapes
lceExtract
lceExtractArea
lceExtractAreas
lceExtractNet
lceExtractNets
lceExtractUnverifiedAreas
lceGetExtractLayers
lceGetFracturedShapes
lceGetFracturedShapesFromNet
lceGetIncompleteNetMarkers
lceGetIncompleteNets
lceGetNetNamesFromArea
lceGetOption
lceGetShortMarkers
lceHiExtract
lceHierExtract
lceIsExtractLayer
lceIsShapeTrimmed
lcePrintConstraintGroupWarnings
lcePrintExtractLayers
lcePrintExtractVias
lcePrintTechDiagnostics
lceRegenerateVoidShapes
lceSetOption
lceShortLocatorChaseAndSave
lceShortLocatorRaiseForm
lconc
ldtrDefReadOA
ldtrDefWriteOA
ldtrLefReadOA
ldtrLefWriteOA
leAlign
leApplyAreaFunction
leApplyLastCopyTransform
leArrowFunc
leAttachFig
leBalloonCycleThru
leBalloonToggleOnOff
leCARCommand
leCARReloadReplays
leCARStartCapture
leCARStopCapture
leChopShape
leClearAllMeasurement
leCloseWindow
leComputeAreaDensity
leComputeFigArea
leConvertInstToMosaic
leConvertMosaicToModgen
leConvertPolygonToPath
leConvertSelectedDynamicShapes
leConvertShapeToPathSeg
leConvertShapeToPolygon
leConvertTrimmedShapesToPRStyle
leCopyTemplatesToCellView
leCreateAutoPin
leCreateLayerField
leCreateMeasurement
leCreateNetField
leCreatePath
leCreatePin
leCycleSnapModes
leCycleSnapPatternDisplay
leDecrementStopLevelByOne
leDefineExternalPins
leDefineInternalPins
leDefineMPPTemplate
leDefinePPPins
leDefineWeaklyConnectedPins
leDescend
leDesignSummary
leDoubleClick
leEIPZoomAbsoluteScale
leEditDesignProperties
leEditInPlace
leEnableInstPropEditFields
leEnvLoad
leExportLabel
leFinishTrunk
leFinishWire
leFlattenInst
leFreezeInst
leFullSelectFigOfSelSet
leGetAreaEstimationDisplayNames
leGetAreaEstimatorFunction
leGetAreaEstimatorParamList
leGetAreaEstimatorRunMode
leGetCoordinateForm
leGetEditFigGroup
leGetEntryLayer
leGetEnv
leGetGlobalGridsVisible
leGetLocalGridsVisible
leGetObjectSelectable
leGetObjectVisible
leGetRefPoint
leGetSnapOptions
leGetSnapPatternVisible
leGetSnapToSPTransform
leGetSnapTransform
leGetTechFormList
leGetValidLayerList
leGetValidPurposeList
leGetWidthSpacingGridsVisible
leGetWidthSpacingSnapPatternVisible
leGetWirebondProfileVisible
leHiAbout
leHiAddShapeToNet
leHiAddToGroup
leHiAddWireVia
leHiAlign
leHiAreaDensity
leHiAssignNet
leHiAttach
leHiBatchChecker
leHiCancelStitch
leHiCellviewTrackPatterns
leHiChop
leHiClearMeasurement
leHiClearMeasurementInHier
leHiClearRuler
leHiConvertInstToMosaic
leHiConvertMosaicToInst
leHiConvertMosaicToModgen
leHiConvertPolygonToPath
leHiConvertShapeToPathSeg
leHiConvertShapeToPolygon
leHiCopy
leHiCreateAreaBoundary
leHiCreateBend
leHiCreateBlockage
leHiCreateBus
leHiCreateChoiceOfPin
leHiCreateCircle
leHiCreateClusterBoundary
leHiCreateClusters
leHiCreateDonut
leHiCreateEllipse
leHiCreateGeometricWire
leHiCreateGroup
leHiCreateGuardRing
leHiCreateInst
leHiCreateLabel
leHiCreateMPP
leHiCreateMeasurement
leHiCreatePRBoundary
leHiCreatePath
leHiCreatePin
leHiCreatePinsFromLabels
leHiCreatePlacementArea
leHiCreatePolygon
leHiCreateRect
leHiCreateRow
leHiCreateRuler
leHiCreateSlot
leHiCreateSnapBoundary
leHiCreateStrandedWire
leHiCreateTaper
leHiCreateTrl
leHiCreateVia
leHiCreateWire
leHiDelete
leHiDeleteAllAreaViewLevel
leHiDeleteAreaViewLevel
leHiDeleteShapeFromNet
leHiDescend
leHiDisplayPadOpeningInfoForm
leHiDisplayStartRouterForm
leHiDisplayTechGraphForm
leHiEditBalloonOptions
leHiEditDRDOptions
leHiEditDRDRuleOptions
leHiEditDisplayOptions
leHiEditDynamicMeasurementOptions
leHiEditEditorOptions
leHiEditInPlace
leHiEditObjectInfo
leHiEditProp
leHiEditSlot
leHiFlatten
leHiFlip
leHiIncrementalViolation
leHiIncrementalViolationUpdater
leHiLayerGen
leHiLayerTap
leHiMakeCell
leHiMarkNet
leHiMerge
leHiModifyCorner
leHiMousePopUp
leHiMove
leHiMoveOrigin
leHiOptionLayer
leHiP2P
leHiPaste
leHiPlotQueueStatus
leHiPropagateNets
leHiQuery
leHiQuickAlign
leHiReShape
leHiRemasterInstances
leHiRemoveFromGroup
leHiRepeatCopy
leHiRotate
leHiSave
leHiSaveACopy
leHiSaveAllHighLightMarkNet
leHiSaveHier
leHiSearch
leHiSetAreaViewLevel
leHiSetRefPoint
leHiShowAngles
leHiShowCoords
leHiShowSelSet
leHiSize
leHiSplit
leHiStitchToLayer
leHiStretch
leHiSubmitPlot
leHiSummary
leHiTree
leHiUnassignNet
leHiUngroup
leHiUnmarkNet
leHiUnmarkNetAll
leHiYank
leIOZoomToFigGroupTopLevelContext
leIncrementStopLevelByOne
leIsAnyMarkNetHighLighted
leIsEXLAppOrAbove
leIsFigSelectable
leIsInstSelectable
leIsLayerSelectable
leIsLayerValid
leIsLayerVisible
leIsLayoutAppOrAbove
leIsLayoutViewerAppEnabled
leIsLayoutViewerWindow
leIsMXLAppOrAbove
leIsNewODCInfraEnabled
leIsPinSelectable
leIsPointInsideFig
leIsRefPointActive
leIsXLAppOrAbove
leLSWGetBlockageSelectable
leLSWGetBlockageVisible
leLSWGetRoutingGridVisible
leLSWSetBlockageSelectable
leLSWSetBlockageVisible
leLSWSetRoutingGridVisible
leLSWSetTrackPatternVisible
leLayerAnd
leLayerAndNot
leLayerOr
leLayerSize
leLayerXor
leLayoutAppNames
leLayoutViewTypes
leLmbCtrlOption
leLmbShiftOption
leMakeCell
leMakeHierReadonlyOrEditableMC
leMarkNet
leMarkNetGetNumThreads
leMergeShapes
leMicroEdit
leModifyCorner
leMoveCellViewOrigin
leMoveCursor
leMoveCursorToRefPoint
lePasteFigs
lePinModelInitFunction
lePlGetApplyPrevData
lePlGetEditorName
lePlot
lePrintHierarchyTree
leQuickAlignToggleMode
leRaiseLSW
leRegAreaEstimator
leRegClusterBdyEstimator
leRegUserLayerSelectionFilter
leRegUserObjectSelectionFilter
leRegisterPPNetNameFn
leRegisterUseGravity
leRemasterInstances
leRepeatCopyMoveStretch
leReplace
leReplaceAnyInstMaster
leReportTrimmedShapesInCustomStyle
leResizeLSW
leReturn
leReturnToLevel
leReturnToTop
leSaveMarkNet
leSearchHierarchy
leSelBoxOrStretch
leSetAllGridObjectsVisible
leSetAllLayerSelectable
leSetAllLayerValid
leSetAllLayerVisible
leSetAllObjectsSelectable
leSetAllObjectsVisible
leSetAreaEstimatorParameters
leSetEditFigGroup
leSetEntryLayer
leSetEnv
leSetFocusToEditableFieldsInStatusToolbar
leSetFormSnapMode
leSetGlobalGridsVisible
leSetInstSelectable
leSetLSWFilter
leSetLayerAttributes
leSetLayerSelectable
leSetLayerValid
leSetLayerVisible
leSetLocalGridsVisible
leSetObjectSelectable
leSetObjectVisible
leSetPinSelectable
leSetRefPoint
leSetRefPointInactive
leSetSnapPatternVisible
leSetStopLevelToEditLevel
leSetStopLevelToMaxHierDepth
leSetWidthSpacingSnapPatternVisible
leSetWirebondProfileVisible
leSizeShape
leSlice
leSpaceBarFunc
leSplitShape
leStartRouter
leStretchFig
leStretchShape
leToggleAllGravity
leToggleAutoZoomPan
leToggleDrdMode
leToggleGravity
leToggleKeepFirstName
leToggleMagnifier
leToggleMaintainConnections
leToggleRuleGravity
leToggleSmartSnap
leUnRegAreaEstimator
leUnRegClusterBdyEstimator
leUnfreezeInst
leUniquifyCellView
leUnmarkNet
leUnregUserLayerSelectionFilter
leUnregUserObjectSelectionFilter
leUnregisterUseGravity
leUpdateInstanceCDFParameterValues
leWECycleControlWire
leWECycleSnap
leWENoSnap
leYankFigs
leZoomToPoint
leZoomToSelSet
leafValue
leftEdge
leftshift
leiDiscardEdits
length
leqp
lessp
let
letrec
letseq
linRg
lindex
lineread
linereadstring
list
listAlias
listFunctions
listToVector
listVariables
listp
lmCheckTerm
lmCheckView
lmCloseLib
lmDefTermProp
lmDefViewProp
lmDeleteTermProp
lmDeleteViewProp
lmGetValue
lmLoadData
lmOpenLib
lmPrintLibTermProp
lmPrintLibViewProp
lmPrintTerm
lmPrintTermProp
lmPrintViewProp
lmReset
lmSimView
lmgrAddMenuItems
lmgrAddToolBarItems
lmgrCreateMenu
lmgrCreateMenuItem
lmgrDefineInits
lmgrDeleteMenuItems
lmgrDisplayMessage
lmgrGetObject
lmgrInsertMenuItems
lmgrLogShowPopup
lmgrManageMenuItems
lmgrMenuSubsInPopup
lmgrQueryNamedObjects
lmgrRemoveToolBarItems
lmgrSensitizeMenuItems
lmgrSetObject
lmgrShowToolBar
lmgrValidateIcon
lmgrVerbose
ln
lntComputeNeighbors
lntContSteps
lntGetAllTraces
lntGetCurrentStep
lntGetSavedViewNames
lntGetTailVal
lntGetTraceInfo
lntHiEditTrace
lntHiNetTracer
lntHideNeighbors
lntIsNeighborsVisible
lntIsStepTrace
lntNeighbors
lntNextStep
lntNextToSetStep
lntPrevStep
lntRemoveAll
lntRemoveAllTraces
lntRemoveTrace
lntSaveTraces
lntSetCurrentStep
lntSetTailVal
lntSetTraceColor
lntSetTraceVisibility
lntShowHideAllTraces
lntShowNeighbors
load
loadContext
loadPort
loadStability
loadTopContextForms
loadi
loadpull
loadstring
lobAddCopyFill
lobBaseLayerDummyFillCB
lobBaseLayerDummyFillWrapperCB
lobGetRegUserProc
lobGetRegisteredAdjacentFillDefsProc
lobGetRegisteredFillOverrideParameters
lobGetRegisteredTransitionFillDefsProc
lobIsCopyFill
lobRegUserProc
lobRegisterAdjacentFillDefsProc
lobRegisterFillOverrideParameters
lobRegisterTransitionFillDefsProc
lobRemoveCopyFill
lobUnRegUserProc
lobUnRegisterAdjacentFillDefsProc
lobUnRegisterTransitionFillDefsProc
lobUnregisterFillOverrideParameters
log
log10
logRg
lowerCase
lowerLeft
lsb
lshift
lsprintf
lxAbutGetNeighbors
lxChain
lxChainAnchor2D
lxCheck
lxCheckAgainstSource
lxCheckAndUpdate
lxCheckAndUpdateRegister
lxCheckAndUpdateRemove
lxCheckAndUpdateSet
lxCheckLib
lxCmdOptions
lxCmdShiftOptions
lxComputeViaParams
lxConvertSlotToPolygon
lxCreateBndFile
lxCreateGroupArray
lxCreateSynchronousClonesFromFigGroups
lxDeleteSchematicDummies
lxDeleteSynchronousCloneFamily
lxDeleteVirtualPins
lxDressingTemplateEditor
lxEditPinPlacement
lxEditPlacementStyle
lxFold
lxGenFromSource
lxGenerateFinish
lxGenerateStart
lxGetAvailablePinLPPs
lxGetCloneFamilyName
lxGetConnRef
lxGetEditedSyncClone
lxGetGroupArrayParams
lxGetOtherClonesInFamily
lxGetPermutedInstTerms
lxGetPinNets
lxGetSchematic
lxGetSource
lxGetSyncClone
lxGetValidViaDefs
lxGetVirtualFigGroupMasterName
lxGroupArrayCreatePreset
lxHiAbout
lxHiAdjustAreaBoundary
lxHiAdjustBoundary
lxHiAlign
lxHiAutoPlace
lxHiBackAnnotateAllActiveDummies
lxHiBackAnnotateDummies
lxHiBackAnnotateSelectedDummies
lxHiChain
lxHiCheck
lxHiCheckAllTerminalInterfaces
lxHiClone
lxHiConnectInstPin
lxHiConvertMosaicToGroupArray
lxHiCreateGroup
lxHiCreateInstFromSch
lxHiCreateMPP
lxHiCreatePinsFromLabels
lxHiCreateVirtGroup
lxHiDefineDeviceCorr
lxHiDesignPlanningOptions
lxHiEditComponentTypes
lxHiGenerateSelectedFromLayout
lxHiGenerateSelectedVirtualHierarchy
lxHiGenerateVirtualHierarchy
lxHiIChain
lxHiLockSelected
lxHiMakeCell
lxHiMakeVirtualHierarchy
lxHiMoveAutomatically
lxHiPRBoundaryInteriorHalo
lxHiPlaceBoundaryCell
lxHiPlaceFiller
lxHiProbe
lxHiReInitDesign
lxHiRemaster
lxHiSetOptions
lxHiSnapPatternOptions
lxHiStack
lxHiSwap
lxHiUnlockSelected
lxHiUpdateAllTerminalInterfaces
lxHiUpdateBinding
lxHiUpdateBusTerminals
lxHiUpdateCellViewPair
lxHiUpdateComponentsAndNets
lxHiUpdateLayoutConstraints
lxHiUpdateLayoutParameters
lxHiUpdateSchematicParameters
lxHiUpdateTerminalNetExpressions
lxHiVerifyDesign
lxHiVirtHierOptions
lxHierCheck
lxHierCheckAgainstSource
lxHierUpdateComponentsAndNets
lxIsGroupArray
lxIsGroupArrayEnabled
lxIsGroupArrayLocked
lxIsGroupArrayRegular
lxIsVirtualFigGroup
lxLaunchLayoutEXL
lxLaunchLayoutMXL
lxLaunchLayoutXL
lxMakeDummy
lxMakePrBoundarySelectable
lxMakePrBoundaryUnselectable
lxMakeVirtualHierarchy
lxMovePorts
lxPermPermutePins
lxProbeRemoveAll
lxRegPostUpdateComponentsAndNets
lxRegPrePosition
lxRegPreUpdateComponentsAndNets
lxRemoveSynchronousCloneFromFamily
lxRunCmdInVXL
lxRunCmdInXL
lxSelectSynchronousFamily
lxSelectedDeleteNetRouting
lxSelectedExtendChain
lxSelectedExtendExpanded
lxSelectedExtendSchematic
lxSelectedLock
lxSelectedLockNet
lxSelectedRemoveIgnore
lxSelectedRoute
lxSelectedRouteNet
lxSelectedSelectAttachedGlobalNets
lxSelectedSelectAttachedNets
lxSelectedSelectAttachedSignalNets
lxSelectedSelectExternalGlobalNets
lxSelectedSelectExternalNets
lxSelectedSelectExternalSignalNets
lxSelectedSelectInternalGlobalNets
lxSelectedSelectInternalNets
lxSelectedSelectInternalSignalNets
lxSelectedSelectNetsShapes
lxSelectedUnlock
lxSelectedUnlockNet
lxSelectedUpdateFromSource
lxSelectedUpdateIgnore
lxSetAreaEstimationOptions
lxSetBoundaryOptions
lxSetCloneFamilyName
lxSetConfigRef
lxSetConnRef
lxSetGenerateOptions
lxSetGroupArrayLocked
lxSetGroupArrayRegular
lxSetNetPinSpecs
lxSetPreserveFloorplanningOptions
lxSetSchematicDriven
lxSetUpdateOptions
lxShapeSlotting
lxShowCommonIncompleteNetsForSelectedInsts
lxShowHideIncompleteNets
lxToggleLocalAbutment
lxToggleShowAllIncompleteNets
lxToggleShowIncompleteNets
lxUnSlotVia
lxUnfold
lxUnregMasterDiffName
lxUnregPrePosition
lxUpdateAllPhysBinding
lxUpdateBinding
lxUpdateComponentsAndNets
lxUpdateComponentsAndNetsFinish
lxUpdateComponentsAndNetsStart
lxUpdateGroupArrayParams
lxUpdatePhysBinding
lxUpdatePlacementStatus
lxVerifyCloneFamily
lxVirtHierGetTermName
lxVirtualHierarchyMakeCell
maeAddFaultRule
maeAddFaultsToFaultGroup
maeAddOutput
maeAddPostRunScript
maeAddPreRunScript
maeAddRelxSetup
maeAddUndetectedFaultsFromHistoryToGroup
maeApplyCornerEditingOptions
maeChangeTypeFromExprToFaultExpr
maeClearAllTestJobPolicies
maeClearExistingFaultsForRevalidation
maeClearTestJobPolicy
maeCloseCornersSetupForm
maeCloseResults
maeCloseSession
maeCloseViolationDb
maeConvertAndCombineMultiADELToAssembler
maeConvertViewForIntegratedHistoryManagement
maeConvertViewForReferencedAndLocalRunPlanCorners
maeConvertViewForSeparateHistoryManagement
maeCopyFaultGroups
maeCopyRelxSetup
maeCopySimulationOptions
maeCopyTestToRun
maeCreateNetlistForCorner
maeCreateNetlistForRel
maeCreateNewRun
maeCreateOrRenameFaultGroup
maeCreateRunCondition
maeCreateRunCopy
maeCreateTest
maeDeleteCorner
maeDeleteExplorerHistory
maeDeleteFaultGroup
maeDeleteFaultRule
maeDeleteMultiWildCardOutputs
maeDeleteOutput
maeDeleteParameter
maeDeleteRelxSetup
maeDeleteRun
maeDeleteRunCondition
maeDeleteSimulationData
maeDeleteTags
maeDeleteTest
maeDeleteVar
maeDisplayLogDiagnostics
maeEditFaultRule
maeEditSimulationOptions
maeEnableCorner
maeEnableFaults
maeEnableGlobalVar
maeEnableParameter
maeEnableRun
maeEnableTests
maeExportCornersToCSV
maeExportCornersToSDB
maeExportGlobalVariablesToCSV
maeExportOutputView
maeExportRunPreview
maeExportSetupForExplorer
maeForceRdbStatus
maeGenerateFuSaReport
maeGetAllExplorerHistoryNames
maeGetAllJobPolicies
maeGetAllPlottingTemplates
maeGetAnalysis
maeGetCornerEditingOptions
maeGetCurrentRunMode
maeGetCurrentRunPlanName
maeGetDUTForFaults
maeGetEnabledAnalysis
maeGetEnabledRuns
maeGetEnvOption
maeGetExplorerTestName
maeGetFaultGroupToRun
maeGetFaultGroups
maeGetFaultRule
maeGetFaultRules
maeGetFaultSamplingOptions
maeGetFaults
maeGetGlobalFaultOptions
maeGetHistoryCloudUUID
maeGetHistoryLockFlag
maeGetHistoryNameForCurrentRunInRunPlan
maeGetJobControlMode
maeGetJobPolicy
maeGetJobPolicyByName
maeGetMTSBlock
maeGetMTSMode
maeGetMappingForJobAndPoint
maeGetNBestDesignPoints
maeGetNumberOfExecutedRuns
maeGetNumberOfUndetectedFaultsFromHistory
maeGetOutputValue
maeGetOverallSpecStatus
maeGetOverallYield
maeGetParamConditions
maeGetParameter
maeGetReferenceHistories
maeGetReliabilityAnalysisEnabled
maeGetReliabilityModel
maeGetReliabilityOptionVal
maeGetReliabilityVarValue
maeGetRelxSetupEnabled
maeGetRelxSetups
maeGetRelxStressFile
maeGetRelxTest
maeGetRelxTestEnabled
maeGetResultOutputs
maeGetResultTests
maeGetResultsViewSelectedCellsDetails
maeGetRunPlan
maeGetSessions
maeGetSetup
maeGetSetupLibrary
maeGetSimOption
maeGetSimulationMessages
maeGetSpecStatus
maeGetStressFile
maeGetTags
maeGetTestEnvVar
maeGetTestOutputs
maeGetTestSession
maeGetVar
maeHasTestJobPolicy
maeImportHistory
maeImportSetupForExplorer
maeIsEvaluatorProcess
maeIsFinalRunCompleted
maeIsFirstRunInRunPlan
maeIsNetlistProcess
maeIsPrerunScriptEnabled
maeIsSetupModified
maeIsSingleTest
maeIsValidMaestroSession
maeLoadCorners
maeLoadSetupState
maeLoadStateForTest
maeMakeEditable
maeMakeReadonly
maeMergeFaultHistories
maeMigrateADELStateToMaestro
maeMigrateADEXLToMaestro
maeOpenLogViewer
maeOpenResults
maeOpenSetup
maeOpenViolationDb
maePlotWithPlottingTemplate
maePrintFaultDroppingStatistics
maeReadResDB
maeRefreshViolationDisplay
maeRegTimer
maeRenameRelxSetup
maeResetCornerEditingOptions
maeRestoreHistory
maeResumeSimulation
maeRunDspfChecker
maeRunFaultSimulationWithFaultDroppingForActiveTests
maeRunLogDiagnostics
maeRunSimulation
maeSaveFaultsRunCount
maeSaveImagesUsingPlottingTemplate
maeSaveSetup
maeSaveSetupState
maeSaveSetupStateForOptimization
maeSensDeleteModel
maeSensDeleteModelGroup
maeSensDeleteParameter
maeSensDeleteVar
maeSensEnableDesignVariation
maeSensEnableStatVariation
maeSensGetModel
maeSensGetModelGroup
maeSensGetModels
maeSensGetParameter
maeSensGetParameters
maeSensGetVar
maeSensGetVars
maeSensSetMethod
maeSensSetModel
maeSensSetModelGroup
maeSensSetParameter
maeSensSetVar
maeSetAnalysis
maeSetCorner
maeSetCornerEditingOptions
maeSetCurrentRunMode
maeSetDUTForFaults
maeSetDesign
maeSetEnableTestVar
maeSetEnvOption
maeSetFaultGroupToRun
maeSetFaultSamplingOptions
maeSetGlobalFaultOptions
maeSetHistoryLock
maeSetJobControlMode
maeSetJobPolicy
maeSetMTSBlock
maeSetMTSMode
maeSetParameter
maeSetPreRunScript
maeSetReliabilityAnalysisEnabled
maeSetReliabilityModel
maeSetReliabilityOptionVal
maeSetReliabilityVarValue
maeSetRelxSetupEnabled
maeSetRelxStressFile
maeSetRelxTest
maeSetRelxTestEnabled
maeSetRunOption
maeSetSetup
maeSetSetupLibrary
maeSetSimOption
maeSetSpec
maeSetStartingPointForOptimization
maeSetTags
maeSetTestEnvVar
maeSetVar
maeStmConsolidateStimuli
maeStmGenerateWaveforms
maeStopAllJobs
maeStopJob
maeStopSimulation
maeSuspendSimulation
maeSwitchActiveFaultGroupForCurrentRun
maeUnWaiveViolation
maeUpdateImplicitSignals
maeWaitUntilDone
maeWaiveViolation
maeWriteDatasheet
maeWriteScript
mag
makeInstance
makeNamespace
makeSymbol
makeTable
makeTempFileName
makeVector
map
mapc
mapcan
mapcar
mapcon
mapinto
maplist
max
mbGetAction
mbRegisterAction
mbRegisterCustomMenu
mbRegisterHierMenu
mbRegisterMenuItem
mbSetContextData
mbUnregisterAction
measureAcross
measureTime
memoryAllocated
menuTrigger
mgAbutAllCB
mgAbutCB
mgAddBodyContact
mgAddCopyDummies
mgAddDummyBottomCB
mgAddDummyLeftCB
mgAddDummyRCBottomCB
mgAddDummyRCLeftCB
mgAddDummyRCRightCB
mgAddDummyRCTopCB
mgAddDummyRightCB
mgAddDummyTopCB
mgAddEmptyRCCB
mgAddGuardRingCB
mgAddShapeToTopo
mgAddTopologyToModgen
mgCreateMatchGroupInModgen
mgCreateModgenAsLayout
mgCreateModgenConstraintAsLayout
mgCreateOrEdit
mgDeleteAllBodyContacts
mgDeleteAllDummies
mgDeleteAllEmptyRowColumnCB
mgDeleteCB
mgDeleteEmptyRowColumnCB
mgDestroyMatchGroupOnObject
mgEditGuardRingCB
mgEvalInBackgroundModgen
mgExecNoConObs
mgExitCB
mgFGREnterHandEdit
mgFGRExitHandEdit
mgFGRIsHandEdit
mgFlattenModgens
mgFlipHorizontalCB
mgFlipVerticalCB
mgGetBoxLPPArea
mgGetChannelTrunks
mgGetColumnRoutingChannelWidth
mgGetConstraintFromFG
mgGetDummyRefDirectionParams
mgGetGuardRingConnectObject
mgGetIsLocalTrunk
mgGetLayerSpacing
mgGetMatchGroupMembers
mgGetModgenConstraintFromTopology
mgGetModgenFGFromConstraint
mgGetModgenFigGroupFromTopology
mgGetRegUserProc
mgGetRegisteredDummyNetProc
mgGetRegisteredDummyOverrideParameters
mgGetRowRoutingChannelWidth
mgGetStrapDirection
mgGetStrapHasDirection
mgGetStrapHasOffset
mgGetStrapLongOffset1
mgGetStrapOffset
mgGetTopoShapes
mgGetTopoTrunkShapes
mgGetTopologyFromModgen
mgGetTrunkChannel
mgGetTrunkRefLPPEnclosure
mgGetTrunkRefLayerPurpose
mgGetTrunkTopo
mgHilightEmptyRowColumnCB
mgIsInBackAnnotation
mgIsTopologyInsideModgen
mgModgenHasTopology
mgObjectHasMatchGroup
mgRegUserProc

mgRegenerateModgen
mgRegisterDummyNetProc
mgRegisterDummyOverrideParameters
mgRegisterDummyParamsRefDirection
mgRemoveMemberFromMatchGroup
mgRemoveTopologyFromModgen
mgRotateLeftCB
mgRotateMXCB
mgRotateMYCB
mgRotateR270CB
mgRotateR90CB
mgRotateRightCB
mgRouteCB
mgRoutePToTCB
mgSelectRowColCB
mgSetColumnRoutingChannelWidth
mgSetIsLocalTrunk
mgSetRowRoutingChannelWidth
mgSetStrapDirection
mgSetStrapHasDirection
mgSetStrapHasOffset
mgSetStrapLongOffset1
mgSetStrapLongOffset2
mgSetStrapOffset
mgSetTrunkRefLayerPurpose
mgSwapCB
mgUnAbutCB
mgUnRegUserProc
mgUnRegisterDummyNetProc
mgUnregisterDummyOverrideParameters
mgUnregisterDummyParamRefDirection
mgUpdateCB
mgUpdateEmptyRowColumnHilightCB
mgUpdateHoriAlignCB
mgUpdateVertAlignCB
min
minus
minusp
mod
modelFile
modf
modulo
monitor
mouseAddPt
mouseAddSelectPt
mouseFinishPt
mousePopUp
mouseSingleSelectPt
mouseSubSelectPt
mouseUndoPt
mprocedure
mptActivate
mptCheckFlow
mptCheckHierarchicalLocks
mptCleanClusters
mptCleanColoredDataOnSingleMaskLayer
mptColorRemastering
mptDefineFlow
mptDeleteClusters
mptDoColorChecks
mptDoToolbarAction
mptFixCVUncoloredAndUnlocked
mptGetColorShiftingLayers
mptGetColoredPurposes
mptGetDefaultColoringMethod
mptGetFlowNames
mptGetFlowSettings
mptGetLayerColoringMethod
mptGetLayerDefaultColor
mptGetLayerDefaultColorSetting
mptGetLockDefaultColors
mptGetOutdatedDesigns
mptGetTrackPatternPattern
mptGetUpToDateDesigns
mptHiStitch
mptHiUnStitch
mptIsMaskColorShown
mptLPPMergeToColor
mptLockAll
mptMarkersToColoredBlockages
mptMarkersToMaskColors
mptPropagateLocks
mptPropagateSameMaskGroups
mptPurgePcell
mptReColor
mptReColorFromShapes
mptReColorSelection
mptReColorWsp
mptReconstructStitch
mptReportColoredShapesOnSingleMaskLayer
mptReportCurrentSettings
mptSetDefaultColoringMethod
mptSetFlow
mptSetLayerColoringMethod
mptSetLayerDefaultColor
mptSetLockDefaultColors
mptSetTrackPatternPattern
mptSetupComplianceChecker
mptShowMaskColor
mptUnlockAll
mptUnpropagateLocks
mptUpdateColor
msgHelp
mspDisplaySetPartSetupForm
mspEditIEProps
mspsMapNetName
mu
mu_prime
muffleWarnings
nameToColor
nc
nc_freq
nc_gain
nclRunConstraintValidation
nclToggleCAEMode
nconc
ncons
nearlyEqual
needNCells
negativep
neq
nequal
netlist
newWindow
newline
next
nextMethodp
nf
nfmin
nindex
nlDisplayOption
nlError
nlGetCdf
nlGetCellName
nlGetCurrentSwitchMaster
nlGetDesign
nlGetFormatter
nlGetGlobalNets
nlGetId
nlGetLibName
nlGetModelName
nlGetNetlistDir
nlGetNetlistedStopCellViewList
nlGetNetlister
nlGetNumberOfBits
nlGetOption
nlGetOptionNameList
nlGetPCellParamSource
nlGetParamList
nlGetParamStringValue
nlGetScratchInstPcellParamValue
nlGetScratchInstance
nlGetSignalList
nlGetSimName
nlGetSimTerminalNets
nlGetSwitchMaster
nlGetSwitchViewList
nlGetTerminalList
nlGetTerminalNets
nlGetTerminalSignalName
nlGetToolName
nlGetTopCellName
nlGetTopLibName
nlGetTopViewName
nlGetViewName
nlIncludeDbDSPFTextFile
nlIncludeDbSPICEMODELTextFile
nlIncludePspiceFile
nlIncludeSrcFile
nlIncludeVerilogFile
nlIncludeVerilogaFile
nlInfo
nlInitialize
nlIsModelNameInherited
nlIsPcellInstance
nlIsPcellParam
nlIsSmartExtractedView
nlMapGlobalNet
nlObjError
nlPrintComment
nlPrintComments
nlPrintFooter
nlPrintHeader
nlPrintHeaderComments
nlPrintIndentString
nlPrintInst
nlPrintInstComments
nlPrintInstEnd
nlPrintInstName
nlPrintInstParameters
nlPrintInstSignals
nlPrintModelName
nlPrintString
nlPrintStringNoFold
nlPrintSubcktBegin
nlPrintSubcktEnd
nlPrintSubcktFooter
nlPrintSubcktFooterComments
nlPrintSubcktHeader
nlPrintSubcktHeaderComments
nlPrintSubcktName
nlPrintSubcktParameters
nlPrintSubcktTerminalList
nlPrintTopCellFooter
nlPrintTopCellFooterComments
nlPrintTopCellHeader
nlPrintTopCellHeaderComments
nlSetOption
nlSetPcellName
nlTranslateFlatIEPathName
nlWarning
nlambda
nmpAsciiToSysVerilog
nmpCDBAFlatToCDBA
nmpCDBAToCDBAFlat
nmpCDBAToConcept
nmpCDBAToDef
nmpCDBAToGcf
nmpCDBAToGenesis
nmpCDBAToIdent
nmpCDBAToLef
nmpCDBAToPrint
nmpCDBAToSdf
nmpCDBAToSpectre
nmpCDBAToSpectreHDL
nmpCDBAToSpef
nmpCDBAToSpf
nmpCDBAToSpice
nmpCDBAToSysVerilog
nmpCDBAToVHDL
nmpCDBAToVHDL87
nmpCDBAToVHDLAMS
nmpCDBAToVerilog
nmpCDBAToVerilogA
nmpCDBAToVerilogAMS
nmpConceptToCDBA
nmpConceptToDef
nmpConceptToGcf
nmpConceptToGenesis
nmpConceptToIdent
nmpConceptToLef
nmpConceptToPrint
nmpConceptToSdf
nmpConceptToSpectre
nmpConceptToSpectreHDL
nmpConceptToSpef
nmpConceptToSpf
nmpConceptToSpice
nmpConceptToSysVerilog
nmpConceptToVHDL
nmpConceptToVHDL87
nmpConceptToVHDLAMS
nmpConceptToVerilog
nmpConceptToVerilogA
nmpConceptToVerilogAMS
nmpDefToCDBA
nmpDefToConcept
nmpDefToGcf
nmpDefToGenesis
nmpDefToIdent
nmpDefToLef
nmpDefToPrint
nmpDefToSdf
nmpDefToSpectre
nmpDefToSpectreHDL
nmpDefToSpef
nmpDefToSpf
nmpDefToSpice
nmpDefToSysVerilog
nmpDefToVHDL
nmpDefToVHDL87
nmpDefToVHDLAMS
nmpDefToVerilog
nmpDefToVerilogA
nmpDefToVerilogAMS
nmpGcfToCDBA
nmpGcfToConcept
nmpGcfToDef
nmpGcfToGenesis
nmpGcfToIdent
nmpGcfToLef
nmpGcfToPrint
nmpGcfToSdf
nmpGcfToSpectre
nmpGcfToSpectreHDL
nmpGcfToSpef
nmpGcfToSpf
nmpGcfToSpice
nmpGcfToSysVerilog
nmpGcfToVHDL
nmpGcfToVHDL87
nmpGcfToVHDLAMS
nmpGcfToVerilog
nmpGcfToVerilogA
nmpGcfToVerilogAMS
nmpGenesisToCDBA
nmpGenesisToConcept
nmpGenesisToDef
nmpGenesisToGcf
nmpGenesisToIdent
nmpGenesisToLef
nmpGenesisToPrint
nmpGenesisToSdf
nmpGenesisToSpectre
nmpGenesisToSpectreHDL
nmpGenesisToSpef
nmpGenesisToSpf
nmpGenesisToSpice
nmpGenesisToSysVerilog
nmpGenesisToVHDL
nmpGenesisToVHDL87
nmpGenesisToVHDLAMS
nmpGenesisToVerilog
nmpGenesisToVerilogA
nmpGenesisToVerilogAMS
nmpGetSpaceNames
nmpIdentToCDBA
nmpIdentToConcept
nmpIdentToDef
nmpIdentToGcf
nmpIdentToGenesis
nmpIdentToLef
nmpIdentToPrint
nmpIdentToSdf
nmpIdentToSpectre
nmpIdentToSpectreHDL
nmpIdentToSpef
nmpIdentToSpf
nmpIdentToSpice
nmpIdentToSysVerilog
nmpIdentToVHDL
nmpIdentToVHDL87
nmpIdentToVHDLAMS
nmpIdentToVerilog
nmpIdentToVerilogA
nmpIdentToVerilogAMS
nmpIsLegalCDBA
nmpIsLegalConcept
nmpIsLegalDef
nmpIsLegalGcf
nmpIsLegalGenesis
nmpIsLegalLef
nmpIsLegalPrint
nmpIsLegalSdf
nmpIsLegalSpectre
nmpIsLegalSpectreHDL
nmpIsLegalSpef
nmpIsLegalSpf
nmpIsLegalSpice
nmpIsLegalSysVerilog
nmpIsLegalVHDL
nmpIsLegalVHDL87
nmpIsLegalVHDLAMS
nmpIsLegalVerilog
nmpIsLegalVerilogA
nmpIsLegalVerilogAMS
nmpLefToCDBA
nmpLefToConcept
nmpLefToDef
nmpLefToGcf
nmpLefToGenesis
nmpLefToIdent
nmpLefToPrint
nmpLefToSdf
nmpLefToSpectre
nmpLefToSpectreHDL
nmpLefToSpef
nmpLefToSpf
nmpLefToSpice
nmpLefToSysVerilog
nmpLefToVHDL
nmpLefToVHDL87
nmpLefToVHDLAMS
nmpLefToVerilog
nmpLefToVerilogA
nmpLefToVerilogAMS
nmpPathCDBAToVHDL
nmpPathCDBAToVerilog
nmpPathNameSpaceToNameSpace
nmpPrintToCDBA
nmpPrintToConcept
nmpPrintToDef
nmpPrintToGcf
nmpPrintToGenesis
nmpPrintToIdent
nmpPrintToLef
nmpPrintToSdf
nmpPrintToSpectre
nmpPrintToSpectreHDL
nmpPrintToSpef
nmpPrintToSpf
nmpPrintToSpice
nmpPrintToSysVerilog
nmpPrintToVHDL
nmpPrintToVHDL87
nmpPrintToVHDLAMS
nmpPrintToVerilog
nmpPrintToVerilogA
nmpPrintToVerilogAMS
nmpSdfToCDBA
nmpSdfToConcept
nmpSdfToDef
nmpSdfToGcf
nmpSdfToGenesis
nmpSdfToIdent
nmpSdfToLef
nmpSdfToPrint
nmpSdfToSpectre
nmpSdfToSpectreHDL
nmpSdfToSpef
nmpSdfToSpf
nmpSdfToSpice
nmpSdfToSysVerilog
nmpSdfToVHDL
nmpSdfToVHDL87
nmpSdfToVHDLAMS
nmpSdfToVerilog
nmpSdfToVerilogA
nmpSdfToVerilogAMS
nmpSpectreHDLToCDBA
nmpSpectreHDLToConcept
nmpSpectreHDLToDef
nmpSpectreHDLToGcf
nmpSpectreHDLToGenesis
nmpSpectreHDLToIdent
nmpSpectreHDLToLef
nmpSpectreHDLToPrint
nmpSpectreHDLToSdf
nmpSpectreHDLToSpectre
nmpSpectreHDLToSpef
nmpSpectreHDLToSpf
nmpSpectreHDLToSpice
nmpSpectreHDLToSysVerilog
nmpSpectreHDLToVHDL
nmpSpectreHDLToVHDL87
nmpSpectreHDLToVHDLAMS
nmpSpectreHDLToVerilog
nmpSpectreHDLToVerilogA
nmpSpectreHDLToVerilogAMS
nmpSpectreToCDBA
nmpSpectreToConcept
nmpSpectreToDef
nmpSpectreToGcf
nmpSpectreToGenesis
nmpSpectreToIdent
nmpSpectreToLef
nmpSpectreToPrint
nmpSpectreToSdf
nmpSpectreToSpectreHDL
nmpSpectreToSpef
nmpSpectreToSpf
nmpSpectreToSpice
nmpSpectreToSysVerilog
nmpSpectreToVHDL
nmpSpectreToVHDL87
nmpSpectreToVHDLAMS
nmpSpectreToVerilog
nmpSpectreToVerilogA
nmpSpectreToVerilogAMS
nmpSpefToCDBA
nmpSpefToConcept
nmpSpefToDef
nmpSpefToGcf
nmpSpefToGenesis
nmpSpefToIdent
nmpSpefToLef
nmpSpefToPrint
nmpSpefToSdf
nmpSpefToSpectre
nmpSpefToSpectreHDL
nmpSpefToSpf
nmpSpefToSpice
nmpSpefToSysVerilog
nmpSpefToVHDL
nmpSpefToVHDL87
nmpSpefToVHDLAMS
nmpSpefToVerilog
nmpSpefToVerilogA
nmpSpefToVerilogAMS
nmpSpfToCDBA
nmpSpfToConcept
nmpSpfToDef
nmpSpfToGcf
nmpSpfToGenesis
nmpSpfToIdent
nmpSpfToLef
nmpSpfToPrint
nmpSpfToSdf
nmpSpfToSpectre
nmpSpfToSpectreHDL
nmpSpfToSpef
nmpSpfToSpice
nmpSpfToSysVerilog
nmpSpfToVHDL
nmpSpfToVHDL87
nmpSpfToVHDLAMS
nmpSpfToVerilog
nmpSpfToVerilogA
nmpSpfToVerilogAMS
nmpSpiceToCDBA
nmpSpiceToConcept
nmpSpiceToDef
nmpSpiceToGcf
nmpSpiceToGenesis
nmpSpiceToIdent
nmpSpiceToLef
nmpSpiceToPrint
nmpSpiceToSdf
nmpSpiceToSpectre
nmpSpiceToSpectreHDL
nmpSpiceToSpef
nmpSpiceToSpf
nmpSpiceToSysVerilog
nmpSpiceToVHDL
nmpSpiceToVHDL87
nmpSpiceToVHDLAMS
nmpSpiceToVerilog
nmpSpiceToVerilogA
nmpSpiceToVerilogAMS
nmpSysVerilogToAscii
nmpSysVerilogToCDBA
nmpSysVerilogToConcept
nmpSysVerilogToDef
nmpSysVerilogToGcf
nmpSysVerilogToGenesis
nmpSysVerilogToIdent
nmpSysVerilogToLef
nmpSysVerilogToPrint
nmpSysVerilogToSdf
nmpSysVerilogToSpectre
nmpSysVerilogToSpectreHDL
nmpSysVerilogToSpef
nmpSysVerilogToSpf
nmpSysVerilogToSpice
nmpSysVerilogToVHDL
nmpSysVerilogToVHDL87
nmpSysVerilogToVHDLAMS
nmpSysVerilogToVerilog
nmpSysVerilogToVerilogA
nmpSysVerilogToVerilogAMS
nmpVHDL87ToCDBA
nmpVHDL87ToConcept
nmpVHDL87ToDef
nmpVHDL87ToGcf
nmpVHDL87ToGenesis
nmpVHDL87ToIdent
nmpVHDL87ToLef
nmpVHDL87ToPrint
nmpVHDL87ToSdf
nmpVHDL87ToSpectre
nmpVHDL87ToSpectreHDL
nmpVHDL87ToSpef
nmpVHDL87ToSpf
nmpVHDL87ToSpice
nmpVHDL87ToSysVerilog
nmpVHDL87ToVHDL
nmpVHDL87ToVHDLAMS
nmpVHDL87ToVerilog
nmpVHDL87ToVerilogA
nmpVHDL87ToVerilogAMS
nmpVHDLAMSToCDBA
nmpVHDLAMSToConcept
nmpVHDLAMSToDef
nmpVHDLAMSToGcf
nmpVHDLAMSToGenesis
nmpVHDLAMSToIdent
nmpVHDLAMSToLef
nmpVHDLAMSToPrint
nmpVHDLAMSToSdf
nmpVHDLAMSToSpectre
nmpVHDLAMSToSpectreHDL
nmpVHDLAMSToSpef
nmpVHDLAMSToSpf
nmpVHDLAMSToSpice
nmpVHDLAMSToSysVerilog
nmpVHDLAMSToVHDL
nmpVHDLAMSToVHDL87
nmpVHDLAMSToVerilog
nmpVHDLAMSToVerilogA
nmpVHDLAMSToVerilogAMS
nmpVHDLToCDBA
nmpVHDLToConcept
nmpVHDLToDef
nmpVHDLToGcf
nmpVHDLToGenesis
nmpVHDLToIdent
nmpVHDLToLef
nmpVHDLToPrint
nmpVHDLToSdf
nmpVHDLToSpectre
nmpVHDLToSpectreHDL
nmpVHDLToSpef
nmpVHDLToSpf
nmpVHDLToSpice
nmpVHDLToSysVerilog
nmpVHDLToVHDL87
nmpVHDLToVHDLAMS
nmpVHDLToVerilog
nmpVHDLToVerilogA
nmpVHDLToVerilogAMS
nmpVerilogAMSToCDBA
nmpVerilogAMSToConcept
nmpVerilogAMSToDef
nmpVerilogAMSToGcf
nmpVerilogAMSToGenesis
nmpVerilogAMSToIdent
nmpVerilogAMSToLef
nmpVerilogAMSToPrint
nmpVerilogAMSToSdf
nmpVerilogAMSToSpectre
nmpVerilogAMSToSpectreHDL
nmpVerilogAMSToSpef
nmpVerilogAMSToSpf
nmpVerilogAMSToSpice
nmpVerilogAMSToSysVerilog
nmpVerilogAMSToVHDL
nmpVerilogAMSToVHDL87
nmpVerilogAMSToVHDLAMS
nmpVerilogAMSToVerilog
nmpVerilogAMSToVerilogA
nmpVerilogAToCDBA
nmpVerilogAToConcept
nmpVerilogAToDef
nmpVerilogAToGcf
nmpVerilogAToGenesis
nmpVerilogAToIdent
nmpVerilogAToLef
nmpVerilogAToPrint
nmpVerilogAToSdf
nmpVerilogAToSpectre
nmpVerilogAToSpectreHDL
nmpVerilogAToSpef
nmpVerilogAToSpf
nmpVerilogAToSpice
nmpVerilogAToSysVerilog
nmpVerilogAToVHDL
nmpVerilogAToVHDL87
nmpVerilogAToVHDLAMS
nmpVerilogAToVerilog
nmpVerilogAToVerilogAMS
nmpVerilogToCDBA
nmpVerilogToConcept
nmpVerilogToDef
nmpVerilogToGcf
nmpVerilogToGenesis
nmpVerilogToIdent
nmpVerilogToLef
nmpVerilogToPrint
nmpVerilogToSdf
nmpVerilogToSpectre
nmpVerilogToSpectreHDL
nmpVerilogToSpef
nmpVerilogToSpf
nmpVerilogToSpice
nmpVerilogToSysVerilog
nmpVerilogToVHDL
nmpVerilogToVHDL87
nmpVerilogToVHDLAMS
nmpVerilogToVerilogA
nmpVerilogToVerilogAMS
nodeset
noise
noiseSummary
normalQQ
normalQQPValue
not
nprocedure
nrDialogAccept
nrGetIndexesFromSelection
nrGetSelectedIndexes
nrListColumnMove
nrListColumnSort
nrListItemAction
nrListItemExpand
nrListItemRename
nrResizeWindow
nrSetCurrentWindow
nrSetFileFilter
nrSetWindowVisibility
nrUpdateMenu
nth
nthcdr
nthelem
null
numConv
numOpenFiles
numberp
occpClose
occpCreateProp
occpGetBestProp
occpGetBitInstProp
occpGetCellProp
occpGetDefaultProp
occpGetInstProp
occpGetPathProp
occpOpen
occpRmBitInstProp
occpRmCellProp
occpRmDefaultProp
occpRmInstProp
occpRmPathProp
occpSave
occpSetBitInstProp
occpSetCellProp
occpSetDefaultProp
occpSetInstProp
occpSetPathProp
ocnAmsSetUNLNetlister
ocnCloseSession
ocnDisplay
ocnDspfFile
ocnGenNoiseSummary
ocnGetAdjustedPath
ocnGetInstancesModelName
ocnHelp
ocnPrint
ocnPrintTMIReliabilityResults
ocnPrintTMIResultTypeList
ocnPspiceFile
ocnResetResults
ocnSetAttrib
ocnSetSilentMode
ocnSetXLMode
ocnSpefFile
ocnWriteLsspToFile
ocnYvsYplot
ocnxPutChecksAssertsTest
ocnxlAddOrUpdateOutput
ocnxlAddRelxScenariosSetup
ocnxlAddRelxSetup
ocnxlBeginTest
ocnxlConjugateGradientOptions
ocnxlCorner
ocnxlCornerVars
ocnxlDeleteNote
ocnxlDisableCorner
ocnxlDisableCornerForTest
ocnxlDisableRelxScenariosSetup
ocnxlDisableRelxSetup
ocnxlDisableSweepParam
ocnxlDisableSweepVar
ocnxlDisableTest
ocnxlEADAddMeasurement
ocnxlEADCreateDataSet
ocnxlEADEnableLiveProcessing
ocnxlEADEnableVoltageConstraints
ocnxlEADSelectAllSignals
ocnxlEADSetDutMaster
ocnxlEADSetHierarchyLevel
ocnxlEADSetWaveFormClipping
ocnxlEnableCorner
ocnxlEnableCornerForTest
ocnxlEnableSweepParam
ocnxlEnableSweepVar
ocnxlEnableTest
ocnxlEndTest
ocnxlEndXLMode
ocnxlExportOutputView
ocnxlFeasibilityAnalysisOptions
ocnxlGetBestPointParams
ocnxlGetCorners
ocnxlGetCurrentHistory
ocnxlGetCurrentHistoryId
ocnxlGetHistory
ocnxlGetJobId
ocnxlGetOverwriteHistory
ocnxlGetOverwriteHistoryName
ocnxlGetPointId
ocnxlGetReferenceHistory
ocnxlGetRunDistributeOptions
ocnxlGetSession
ocnxlGetSpecs
ocnxlGetTests
ocnxlGlobalOptimizationOptions
ocnxlHistoryPrefix
ocnxlJobSetup
ocnxlLoadCurrentEnvironment
ocnxlLoadSetupState
ocnxlLocalOptimizationOptions
ocnxlLocalParametricSet
ocnxlMCIterNum
ocnxlMTSBlock
ocnxlMTSEnable
ocnxlMainSimSession
ocnxlMaxJobFail
ocnxlModelGroup
ocnxlMonteCarloOptions
ocnxlOpenResults
ocnxlOutputAreaGoal
ocnxlOutputExpr
ocnxlOutputMatExpr
ocnxlOutputMatlabScript
ocnxlOutputOceanScript
ocnxlOutputOpRegion
ocnxlOutputSignal
ocnxlOutputSummary
ocnxlOutputTerminal
ocnxlOutputViolations
ocnxlParametricSet
ocnxlPreRunScript
ocnxlProjectDir
ocnxlPutChecksAsserts
ocnxlPutEnabledChecksAssertsCellViews
ocnxlPutGreaterthanSpec
ocnxlPutInfoSpec
ocnxlPutLessthanSpec
ocnxlPutMaxSpec
ocnxlPutMinSpec
ocnxlPutNote
ocnxlPutRangeSpec
ocnxlPutToleranceSpec
ocnxlReEvaluatePointVariables
ocnxlRemoveSpec
ocnxlRenameCurrentHistory
ocnxlResultsLocation
ocnxlRun
ocnxlRunCalibration
ocnxlRunSetupSummary
ocnxlSamplingOptions
ocnxlSaveSetupAs
ocnxlSelectTest
ocnxlSensitivityOptions
ocnxlSensitivityVars
ocnxlSetAllParameterPSetsDisabled
ocnxlSetAllParametersDisabled
ocnxlSetAllVariablePSetsDisabled
ocnxlSetAllVarsDisabled
ocnxlSetCalibration
ocnxlSetDesignVariablePerTest
ocnxlSetMCdut
ocnxlSetMTSMode
ocnxlSetOverwriteHistory
ocnxlSetOverwriteHistoryName
ocnxlSetPreRunScriptEnabled
ocnxlSetReferenceHistory
ocnxlSetRelxAnalysisEnabled
ocnxlSetRelxEnabledForPreRun
ocnxlSetRelxScenariosEnabled
ocnxlSetRunDistributeOptions
ocnxlSetupLocation
ocnxlSimResultsLocation
ocnxlSizeOverCornersOptions
ocnxlStartingPoint
ocnxlStimuliData
ocnxlSweepParam
ocnxlSweepVar
ocnxlSweepsAndCornersOptions
ocnxlTargetCellView
ocnxlUpdatePointVariable
ocnxlWaitUntilDone
ocnxlWorstCaseCornersOptions
ocnxlWriteDatasheet
ocnxlYieldEstimationOptions
ocnxlYieldImprovementOptions
odcRegBlockage
odcRegBoundary
odcRegCPA
odcRegInstance
odcRegLabel
odcRegMarker
odcRegModgen
odcRegPin
odcRegRow
odcRegRowRegion
odcRegRuler
odcRegShapeCircle
odcRegShapeDonut
odcRegShapeEllipse
odcRegShapeMPP
odcRegShapePath
odcRegShapePathSeg
odcRegShapePolygon
odcRegShapeRect
odcRegTextDisplay
odcRegVia
odcRegVirtualFigGroup
odcRegisterCustomFunc
oddp
off
onep
opcAddListToSet
opcAddObjectToSet
opcAllSetsInCellView
opcClearSet
opcCreateCondition
opcCreateExpression
opcCreatePersistentSet
opcCreateQuery
opcDeleteQuery
opcEditQuery
opcFindSet
opcInstantiateQuery
opcLoadQueries
opcSaveQueries
openResults
openportp
option
or
otherp
outfile
outportp
outputParams
outputs
outstring
outstringp
overshoot
pairp
parCacheFind
parCacheGet
parCacheListFilters
parCacheListModels
parCachePurge
parCacheSave
parDelete
parFilterCreate
parFind
parModelCreateCustom
parModelCreateNetC
parModelCreateNetK
parModelCreateNetL
parModelCreateNetR
parModelListSimParams
parModelListSimSweeps
parModelUpdateSimParams
parModelUpdateSimSweeps
parObjectListFilters
parObjectListModels
parRemoveMembers
parResetAllParams
parResetParams
parSetNote
parUpdateMembers
parUpdateParams
paramAnalysis
paramRun
parseString
path
pavg
pcColinearPoints
pcConcatOrient
pcDefineCondition
pcDefineInheritParam
pcDefinePCell
pcDefinePPCell
pcDefineParamCell
pcDefineParamLabel
pcDefineParamLayer
pcDefineParamPath
pcDefineParamPolygon
pcDefineParamProp
pcDefineParamRect
pcDefineParamRefPointObject
pcDefineParamSlot
pcDefinePathRefPointObject
pcDefineRepeat
pcDefineSteppedObject
pcDefineStretchLine
pcDeleteCondition
pcDeleteParam
pcDeleteParamLayer
pcDeleteParamProp
pcDeleteParamShape
pcDeleteRefPoint
pcDeleteRepeat
pcDeleteSteppedObject
pcDraw
pcExprToProp
pcExprToString
pcFilterPoints
pcFix
pcGetBendAngle
pcGetCodeParamNames
pcGetCodeParamValue
pcGetConditions
pcGetDefaultParamsFromClass
pcGetInheritParamDefn
pcGetInheritParams
pcGetOffsetPath
pcGetOffsetPolygon
pcGetParamLabelDefn
pcGetParamLabels
pcGetParamLayerDefn
pcGetParamLayers
pcGetParamProps
pcGetParamShapeDefn
pcGetParamShapes
pcGetParamSlotType
pcGetParamSlotValue
pcGetParameters
pcGetPathRefPoint
pcGetRefPointDefn
pcGetRefPoints
pcGetRepeatDefn
pcGetRepeats
pcGetStepDirection
pcGetSteppedObjectDefn
pcGetSteppedObjects
pcGetStretchDefn
pcGetStretchSummary
pcGetStretches
pcGrowBox
pcGrowPoints
pcHICompileToSkill
pcHIDefineCondition
pcHIDefineInheritedParameter
pcHIDefineLabel
pcHIDefineLayer
pcHIDefineParamCell
pcHIDefineParamRefPointObject
pcHIDefineParameterizedShape
pcHIDefinePathRefPointObject
pcHIDefineProp
pcHIDefineRepeat
pcHIDefineSteppedObject
pcHIDefineStretch
pcHIDeleteCondition
pcHIDeleteLayer
pcHIDeleteParameterizedShape
pcHIDeleteProp
pcHIDeleteRefPointObject
pcHIDeleteRepeat
pcHIDeleteSteppedObject
pcHIDisplayCondition
pcHIDisplayInheritedParameter
pcHIDisplayLayer
pcHIDisplayParameterizedShape
pcHIDisplayParams
pcHIDisplayProp
pcHIDisplayRefPointObject
pcHIDisplayRepeat
pcHIDisplaySteppedObject
pcHIEditParameters
pcHIModifyCondition
pcHIModifyLabel
pcHIModifyLayer
pcHIModifyParams
pcHIModifyRefPointObject
pcHIModifyRepeat
pcHIModifySteppedObject
pcHIModifyStretchLine
pcHIQualifyStretchLine
pcHIRedefineStretchLine
pcHISummarizeParams
pcIsParamSlot
pcModifyParam
pcRedefineStretchLine
pcRestrictStretchToObjects
pcRound
pcSetFTermWidth
pcSetParamSlotValue
pcSetParamSlotsFromMaster
pcSkillGen
pcStepAlongShape
pcTechFile
pcUserAdjustParameters
pcUserGenerateArray
pcUserGenerateInstance
pcUserGenerateInstancesOfMaster
pcUserGenerateLPP
pcUserGeneratePin
pcUserGenerateProperty
pcUserGenerateShape
pcUserGenerateTerminal
pcUserInitRepeat
pcUserPostProcessCellView
pcUserPostProcessObject
pcUserPreProcessCellView
pcUserSetTermNetName
pcdbClose
pcdbGetIgnoredInstMasterGen
pcdbGetInstGen
pcdbGetInstMasterGen
pcdbInstMasterCell
pcdbInstMasterCellFixed
pcdbInstMasterLib
pcdbInstMasterLibFixed
pcdbInstMasterView
pcdbInstMasterViewFixed
pcdbInstName
pcdbInstWidth
pcdbNextInst
pcdbNextInstMaster
pcdbOpen
pcdbSave
pcdbViewHasPcdbInfo
pcreCompile
pcreExecute
pcreGenCompileOptBits
pcreGenExecOptBits
pcreGetRecursionLimit
pcreListCompileOptBits
pcreListExecOptBits
pcreMatchAssocList
pcreMatchList
pcreMatchp
pcreObjectp
pcrePrintLastMatchErr
pcreReplace
pcreSetRecursionLimit
pcreSubpatCount
pcreSubstitute
pdkeqCockpit
peak
peakToPeak
perfDiagInstall
perfRefreshControl
perfStartCallStackProc
perfStopCallStackProc
period_jitter
pfile
pgssDRC
phase
phaseDeg
phaseDegUnwrapped
phaseDegUnwrappedWithFreq
phaseMargin
phaseNoise
phaseRad
phaseRadUnwrapped
phoAddWaveguidePorts
phoBendConnector
phoCompose
phoComputeModeProps
phoCreatePort
phoCurveDeltaConnector
phoDrawBendConnectorSymbol
phoDrawCWLaserSymbol
phoDrawCompWaveguideLayout
phoDrawCompWaveguideSymbol
phoDrawCrossBBSymbol
phoDrawCurveDeltaConnectorSymbol
phoDrawDCSymbol
phoDrawEdgeCouplerBBSymbol
phoDrawMMISymbol
phoDrawPhotoDiodeBBSymbol
phoDrawSBendWaveguideSymbol
phoDrawStraightModulatorSymbol
phoDrawStraightWaveguideSymbol
phoDrawWayPointConnectorSymbol
phoDrawYSplitterSymbol
phoGenWaveguide
phoGetConnectorAnchors
phoHiCompose
phoHiDecompose
phoHiEditCompositeWG
phoIPCGetMessageProcessor
phoIPCGetServerCheck
phoIPCProcessMarkers
phoIPCProcessPorts
phoIPCProcessServerMessage
phoIPCProcessShapes
phoIPCRegisterMessageProcessor
phoIPCRegisterServerCheck
phoIPCServerCheck
phoIsWaveguide
phoOMGetObject
phoRegisterInstTermOpticalMonitorMenuItem
phoSineDeltaConnector
phoStraightConnector
phoTechDeleteModePropDataTable
phoTechGetModePropDataTableParamValues
phoTechHasModeProp
phoTechHasModePropDataTable
phoTechIsModePropLocalOnly
phoTechLoadModePropDataTable
phoWayPointConnector
piCellNameMap
piLayerMap
piPostTranslate
piPreTranslate
piTextMap
pir
pkxAddFuncDefPin
pkxCreateCompDef
pkxCreateCompDefPin
pkxCreateFuncDef
pkxCreateFuncDefPin
pkxDeleteCompDef
pkxFindCompDef
pkxFindCompDefPin
pkxFindFuncDef
pkxFindFuncDefPin
pkxGetCompDefPins
pkxGetCompDefs
pkxGetFuncDefPins
pkxGetFuncDefs
pkxGetProp
pkxGetProps
pkxPadFile
pkxSetProp
pkxUnPadFile
plist
plot
plotStyle
plus
plusp
pmNoise
pn
poCellNameMap
poLayerMap
poParamCellNameMap
poPostTranslate
poPreTranslate
poTextMap
popf
portp
postArrayDec
postArrayInc
postArraySet
postInstallTrigger
postdecrement
postincrement
pow
pp
pprint
preArrayDec
preArrayInc
preArraySet
preXY
predecrement
preincrement
prependInstallPath
prependPath
print
printFunctions
printGraph
printObject
printVariables
printViolations
printf
printlev
println
printself
printstruct
prms
probeTrigger
procedure
procedurep
profile
profileReset
profileSummary
prog
prog1
prog2
progn
psConfigLoaded
psLoadCdsPlotInit
psQueryPaperSize
psQueryPaperSizes
psQueryPlotters
psQueueStatus
psd
psdbb
pstddev
pteCancelForm
pteClearSearchHistory
pteCloseLayerSetEdition
pteCloseMPTSupportMode
pteCollapse
pteCollapseAll
pteContextMenu
pteDeleteLayerSet
pteDeselect
pteDeselectAll
pteDiscardLayerSetEdition
pteDockWindow
pteEditLayerSet
pteEditLayerSetValidity
pteExpand
pteExpandAll
pteExportLayerSet
pteFindNext
pteFindPrev
pteGetActiveScopeModes
pteGetAllActiveLayerSets
pteGetAllLayerSets
pteGetCurrentPanel
pteGetLPPDisplayedInPalette
pteGetLSAtPosition
pteGetLayerPath
pteGetLayerSetColoredLpp
pteGetLayerSetMembers
pteGetMPTSupportMode
pteGetNextLayerSets
pteGetPrevLayerSets
pteGetSelection
pteHideAllTools
pteImportLayerSet
pteInfraGetPaletteMode
pteIsSelectable
pteIsVisible
pteLoadConfig
pteLoadDefaults
pteLoadFromTechFile
pteLoadGDSNumber
pteLoadLSWInfo
pteLoadLayerSet
pteMPTSupportMode
pteMapWindow
pteMinimizeSingleWindowPalette
pteMoveLayerSelection
pteMoveSingleWindowPalette
pteOpenForm
ptePropagateSelectability
ptePropagateVisibility
pteRaiseSingleWindowPalette
pteRegisterUserLSManagerTrigger
pteRegisterUserSelectionTrigger
pteReloadLayerSet
pteResizeSingleWindowPalette
pteSaveAsLayerSet
pteSaveAsSynchronizedLayerSet
pteSaveConfig
pteSaveGDSNumber
pteSaveLSWInfo
pteSaveLayerSet
pteSaveLayerSetList
pteSaveLayerSetListInRepository
pteSaveToTechFile
pteSelect
pteSelectAll
pteSetActiveLpp
pteSetActiveLppColor
pteSetActiveLppColorLock
pteSetAllLSEnable
pteSetAllLayerSetMember
pteSetAllSelectable
pteSetAllStipple
pteSetAllValidity
pteSetAllVisible
pteSetBindkeys
pteSetConfig
pteSetFindModeOn
pteSetLSActive
pteSetLSEnable
pteSetLSPosition
pteSetLSSelectable
pteSetLSVisible
pteSetLayerSetColoredLpp
pteSetLayerSetMember
pteSetLppVisibleByString
pteSetMPTSupportMode
pteSetNoneLayerSetMember
pteSetNoneSelectable
pteSetNoneStipple
pteSetNoneValidity
pteSetNoneVisible
pteSetOnlySelectable
pteSetOnlySelectableWithDepth
pteSetOnlyVisible
pteSetOnlyVisibleWithDepth
pteSetOption
pteSetOptionString
pteSetRoutingDirection
pteSetSearchMatchCase
pteSetSearchMatchType
pteSetSearchOperator
pteSetSearchText
pteSetSelectable
pteSetSelectableWithDepth
pteSetShowLockedColors
pteSetShowUnlockedColors
pteSetStipple
pteSetValidity
pteSetVisible
pteSetVisibleWithDepth
pteSetWindowSynchro
pteShowAllTools
pteShowMPTLPP
pteShowRoutingLPP
pteShowUsedLPP
pteShowValidLPP
pteToggleAllLayerSetMember
pteToggleAllSelectable
pteToggleAllStipple
pteToggleAllTools
pteToggleAllValidity
pteToggleAllVisible
pteToggleLSActive
pteToggleLayerSetEdition
pteToggleLayerSetValidityEdition
pteTogglePanels
pteTogglePropagateAllSelectable
pteTogglePropagateAllVisible
pteToggleShowMPTLPP
pteToggleShowRoutingLPP
pteToggleShowUsedLPP
pteToggleShowValidLPP
pteToggleToolbars
pteToggleWindowSynchro
pteUnRegisterUserLSManagerTrigger
pteUnRegisterUserSelectionTrigger
pteUndockWindow
pteUnmapWindow
pteUnsetLSActive
pushf
putc
putd
putprop
putpropq
putpropqq
pv
pvi
pvifreq
pvr
pvrfreq
pvsApplyDRC
pzFrequencyAndRealFilter
pzPlot
pzSummary
pzbode
pzfilter
quote
quotient
random
range
rapidIIPN
rapidIPNCurves
rapidOIPN
rdbLoadResults
rdbReloadResults
rdbSetCurrentDirectory
rdbShowDialog
rdbUnloadResults
rdbWriteToFormat
rdeCloseSession
rdeCreateChamferFill
rdeCreateWireChamfer
rdeDone
rdeEval
rdeGetVar
rdeHide
rdeInspect
rdeOpenCurrentDesign
rdeRemoveChamferFill
rdeReplay
rdeSequencer
rdeSetVar
rdeShow
rdeSource
read
readTable
readstring
real
realp
regExitAfter
regExitBefore
relxAddReliabilityInStateComponent
relxAddReliabilityOption
relxAddSetupRelxOption
relxCreateCustomizedTab
relxCreateRunObjectFile
relxCustomizeDisplayOrEnableStatus
relxDisplayDiscField
relxDisplayReliabilityForm
relxDisplayResult
relxEnableDiscField
relxEnableFormTab
relxFormatRXControlFile
relxGetCustomTabName
relxGetModifyNetlistVal
relxGetMosAgingTimeUnitVal
relxGetMosAgingTimeVal
relxGetRXControlFileName
relxGetReliabilityOptionChoices
relxGetReliabilityOptionVal
relxGetRelxStage
relxGetSimulationRunCommand
relxGetSpecifiedReliabilityStateFileName
relxGetStressFileDir
relxGetUserCmdLine
relxHideAgeCalculationApproachField
relxHighLightDevices
relxInitAdapterReliabilityOption
relxInitOptionsInCdsenv
relxInitReliabilityOption
relxIsAgingOn
relxIsReliabilityEnabled
relxIsStressOn
relxOption
relxPostSimulation
relxRunSimulation
relxSetAgingVal
relxSetReliabilityOptionFormProperties
relxSetReliabilityOptionVal
relxSetReliabilityVal
remExitProc
remainder
remd
remdq
remoteDir
remove
removeDependent
removeFromExportList
removeLabel
removeListDuplicates
removeMethod
removeShadowImport
remprop
remq
renameFile
report
restore
restoreFloat
resultParam
results
resultsDir
resume
resumeJob
return
reverse
rexCompile
rexExecute
rexMagic
rexMatchAssocList
rexMatchList
rexMatchp
rexReplace
rexSubstitute
rfCimMcpValue
rfEdgePhaseNoise
rfGetEventtimeIndex
rfGetMinDampFactor
rfInputNoise
rfJc
rfJcc
rfJitter
rfOutputNoise
rfThresholdXing
rfTotalPower
rfTransferFunction
rfWrlsCcdfValues
rfWrlsCim3Value
rfWrlsCim5Value
rfWrlsMeasContour
rightEdge
rightshift
rindex
riseTime
risetime
rms
rmsNoise
rmsTerminalVoltage
rmsVoltage
rms_jitter
rn
rodAddMPPChopHole
rodAddPoints
rodAddSubPart
rodAddToX
rodAddToY
rodAlign
rodAssignHandleToParameter
rodCheck
rodCheckAllMPPsInCellView
rodCheckMPPs
rodCoordBisect
rodCoordCreate
rodCoordDefineGrid
rodCoordFix
rodCoordGetGrid
rodCoordIsOnGrid
rodCoordParseString
rodCoordPartition
rodCoordSnap
rodCoordToFloat
rodCoordToInt
rodCoordToString
rodCreateHandle
rodCreatePath
rodCreatePolygon
rodCreateRect
rodDeleteHandle
rodDeleteSubPart
rodFillBBoxWithRects
rodFillWithRects
rodForceUpdate
rodGetBBox
rodGetHandle
rodGetNamedShapes
rodGetObj
rodGetSubPart
rodIsFigNameUnused
rodIsHandle
rodIsMasterChoppable
rodIsObj
rodNameObject
rodNameShape
rodPointX
rodPointY
rodSetMasterChoppable
rodSubPoints
rodUnAlign
rodUnNameShape
root
rotatef
round
round2
rplaca
rplacd
rshift
rteCheckAntenna
rteCheckDataForRouting
rteCheckRoutability
rteComposeTrunks
rteCoverObstructionHilite
rteCoverObstructionUnHilite
rteCreateBlockRingScheme
rteCreateCellRowsScheme
rteCreateCoreRingScheme
rteCreatePadRingScheme
rteCreatePinToTrunkScheme
rteCreateStripesScheme
rteCreateViasScheme
rteDecomposeTrunks
rteDeleteRoutedNets
rteFixAntenna
rteFixViolations
rteGeomAnd
rteGeomAndNot
rteGeomNot
rteGeomOr
rteGeomSize
rteGeomXor
rteOptimizeRoute
rtePowerRouteBlockRing
rtePowerRouteCellRow
rtePowerRouteCoreRing
rtePowerRoutePadRing
rtePowerRoutePinToTrunk
rtePowerRouteStripes
rtePowerRouteTieShield
rtePowerRouteTrimStripes
rtePowerRouteViaInsertion
rteSearchAndRepair
run
runsim
s11
s12
s21
s22
sample
save
saveContext
saveFloat
saveGraphImage
saveOpPoint
saveOption
saveSubckt
schAddIgnoreProp
schAddSelectPt
schAlign
schAttachLibToPackageTech
schCheck
schCheckHier
schCheckHierConfig
schClearConn
schCloneSymbol
schCmdOption
schComputePinRef
schCopy
schCreateInst
schCreateInstBox
schCreateNetExpression
schCreateNoteLabel
schCreateNoteShape
schCreatePin
schCreateSheet
schCreateSplitPrimarySymbol
schCreateSymbolLabel
schCreateSymbolPin
schCreateSymbolShape
schCreateWire
schCreateWireLabel
schDelete
schDeleteIndex
schDeleteSheet
schDeselectAllFig
schDirectEdit
schDistribute
schDrawSymbolPin
schEditPinOrder
schEditSheetSize
schExportSVG
schExtendSelSet
schExtendSelectPt
schExtractConn
schExtractStatus
schFindIgnorePropByName
schGetAllIgnoreProps
schGetBundleDisplayMode
schGetCellViewListInSearchScope
schGetCheckGroups
schGetEnv
schGetIgnoredStatus
schGetMatchingObjects
schGetPinOrder
schGetPostCheckTriggers
schGetPreCheckTriggers
schGetPropertyDisplay
schGetShapeStyle
schGetSignalTypeIntegrity
schGetSplitInstTerms
schGetSplitInstances
schGetSplitPrimaryInst
schGetSplitPrimaryInstTerm
schGetWireColor
schGetWireLineStyle
schGlueLabel
schHDLReturn
schHdlPrintFile
schHdlPrintVars
schHiAbout
schHiAlign
schHiAlternateView
schHiCellViewProperty
schHiChangeEditMode
schHiCheck
schHiCheckAndSave
schHiCheckHier
schHiCloneSymbol
schHiComputePinRef
schHiCopy
schHiCreateBlockInst
schHiCreateInst
schHiCreateInstBox
schHiCreateKanjiSymbol
schHiCreateMappingSchematic
schHiCreateNetExpression
schHiCreateNoteLabel
schHiCreateNoteShape
schHiCreatePatchcord
schHiCreatePin
schHiCreateSheet
schHiCreateSymbolLabel
schHiCreateSymbolPin
schHiCreateSymbolShape
schHiCreateWire
schHiCreateWireLabel
schHiCreateWireStubs
schHiDefaultAction
schHiDelete
schHiDeleteIndex
schHiDeleteSheet
schHiDescend
schHiDescendEdit
schHiDescendRead
schHiDisplayOptions
schHiDistribute
schHiDrawSymbolPin
schHiEditInPlace
schHiEditPinOrder
schHiEditSheetSize
schHiEditText
schHiEditTitleBlock
schHiEditorOptions
schHiEnvSaveLoad
schHiEscape
schHiExtractConn
schHiFind
schHiFindMarker
schHiFlatten
schHiFollowPin
schHiFontUpdate
schHiGotoSheet
schHiGridOptions
schHiHiliteLabel
schHiIgnore
schHiInstToView
schHiMakeCell
schHiMousePopUp
schHiMove
schHiNetExprAvailProps
schHiNetExprEvalNames
schHiNewCellView
schHiObjectProperty
schHiOpenCellView
schHiOpenOtherView
schHiOpenSymbolOrSchematicView
schHiPinListToView
schHiPlot
schHiPlotQueueStatus
schHiRaiseCurrentForm
schHiRegisterWireStubs
schHiRenumberAllSheet
schHiRenumberInstances
schHiRenumberSheet
schHiReplace
schHiResetInvisibleLabels
schHiReturn
schHiReturnToTop
schHiRotate
schHiRouteFlightLine
schHiRouteNamedConnection
schHiSRC
schHiSaveCellView
schHiSelectAll
schHiSelectByProperty
schHiSetOrigin
schHiSetSymbolOrigin
schHiShowScope
schHiSnapToGrid
schHiSolder
schHiStretch
schHiSymStretch
schHiTree
schHiUpdatePinOrder
schHiUpdatePinsFromView
schHiVHDLProperty
schHiVIC
schHiVICAndSave
schHiViewToView
schHiZoomToSelSet
schIgnore
schInhConFind
schInhConSet
schInstToView
schInstallHDL
schIsFlightLine
schIsHDLCapEnabled
schIsInCheckHier
schIsIndexCV
schIsSchEditOk
schIsSheetCV
schIsSplitInst
schIsSplitPrimaryInst
schIsSplitPrimarySymbol
schIsSplitSymbol
schIsSymEditOk
schIsTextEditable
schIsUsingSplitFeature
schIsWire
schIsWireLabel
schLayoutToPinList
schMapMCCleanup
schMapMCCreateTargets
schMapMCFinalizeTargets
schMapMCSaveSourceData
schMapMCSettings
schMouseApplyOrFinish
schMove
schNetExprAvailProps
schNetExprEvalNames
schPinListToSchem
schPinListToSchemGen
schPinListToSymbol
schPinListToSymbolGen
schPinListToVerilog
schPinListToView
schPlot
schProduceCVHierConfig
schProduceUniqueCVHier
schRegPostCheckTrigger
schRegPreCheckTrigger
schRegisterCheckGroup
schRegisterCheckRule
schRegisterFixedMenu
schRegisterPopUpMenu
schReinitializeShapeStyles
schRemoveIgnoreProp
schRenumberAllSheet
schRenumberInstances
schRenumberSheet
schReplaceProperty
schReportCheckFailure
schSRC
schSaveCurrentPlotOptions
schSchemToPinList
schSelectAllFig
schSelectByLine
schSelectPoint
schSetAndLoadTsgTemplateType
schSetBundleDisplayMode
schSetCmdOption
schSetEnv
schSetIgnorePropEnabled
schSetOrigin
schSetPropertyDisplay
schSetSelectOptions
schSetShapeStyle
schSetSignalTypeIntegrity
schSetSplitPrimaryInst
schSetSplitSymbol
schSetSymbolOrigin
schSetTextDisplayBBox
schSetWireColor
schSetWireLineStyle
schShiftCmdOption
schSingleSelectBox
schSingleSelectPt
schSnapToConn
schSnapToGrid
schSolder
schSplitNumber
schStretch
schSubSelectBox
schSymbolToPinList
schSync
schTraceNet
schUnregPostCheckTrigger
schUnregPreCheckTrigger
schUnregisterFixedMenu
schUnregisterPopUpMenu
schUpdateUserSRCErrorAndWarn
schVIC
schVerilogToPinList
schViewToView
schZoomFit
schemeTopLevelEnv
selectResult
set
setContext
setCurrentWindow
setDevCheckOptions
setEFunFlightLineTarget
setFnWriteProtect
setPrompts
setSG
setSaveContextVersion
setShellEnvVar
setSkillPath
setSlotValue
setVarWriteProtect
setarray
setcar
setcdr
setf
setf_arrayref
setf_bottomEdge
setf_caaar
setf_caadr
setf_caar
setf_cadar
setf_caddr
setf_cadr
setf_car
setf_cdaar
setf_cdadr
setf_cdar
setf_cddar
setf_cdddr
setf_cddr
setf_cdr
setf_dynamic
setf_get
setf_getSG
setf_getSGq
setf_getShellEnvVar
setf_getd
setf_getq
setf_getqq
setf_last
setf_leftEdge
setf_lowerLeft
setf_nth
setf_nthcdr
setf_nthedr
setf_nthelem
setf_rightEdge
setf_slotValue
setf_topEdge
setf_upperRight
setf_xCoord
setf_yCoord
setguard
setof
setofs
setplist
setq
setqbitfield
setqbitfield1
settlingTime
setup
sevAboutTool
sevActivateSelectedAnas
sevActiveSelectedAna
sevAddExpression
sevAddMenuItemLists
sevAnnotateResults
sevBALMTool
sevBPMTool
sevChangeOutsOnSchematic
sevChooseDesign
sevChooseEnvironmentOptions
sevChooseSimulator
sevChooseTemperature
sevCircuitCond
sevCloseXmlFile
sevConvergence
sevConvertStateFormat
sevCopyCellViewVariables
sevCopyVariablesToCellView
sevCornersTool
sevCreateMainWindow
sevDebug
sevDeleteResults
sevDeleteSelectedAnas
sevDeleteSelectedOpPoints
sevDeleteSelectedOuts
sevDeleteSelectedSubckts
sevDeleteSelectedVars
sevDeleteSelections
sevDevChecking
sevDirectPlotMenu
sevDisplayViolations
sevEditModels
sevEditOptions
sevEditPlottingOptions
sevEditSelectedAnas
sevEditSelectedOuts
sevEditSelectedVars
sevEditSimulationFile
sevEditStimulus
sevEnvironment
sevEvaluateAndPlotExpressions
sevExportOutputsToCSV
sevExportOutputsToFile
sevExportOutputsToTxt
sevFindSelectedVars
sevGetExpressions
sevGetRegisteredPcellsForAnnotation
sevGetSessionType
sevIcon
sevImportOutputsFromCSV
sevImportOutputsFromFile
sevImportOutputsFromTxt
sevInvokeNCBrowse
sevInvokeSimvision
sevInvokeSimvisionDebugger
sevIsContinuable
sevKmodelTool
sevLMGTool
sevLoadState
sevMTSMode
sevMTSOptions
sevMenuItems
sevMonteCarloTool
sevMpuTool
sevNetlistAndDebug
sevNetlistAndRun
sevNetlistFile
sevNoAnaSelections
sevNoDesign
sevNoEnvironment
sevNoLog
sevNoOutSelections
sevNoOutputLog
sevNoPlottableExpressions
sevNoPlottableOutputs
sevNoPlottableSignals
sevNoResults
sevNoVarSelections
sevNoViolationsFound
sevNonActiveSelectedAna
sevNonMixedSignal
sevOpenCalculator
sevOpenDRLBrowser
sevOpenEncap
sevOpenJobMonitor
sevOpenPlotWindow
sevOpenPrintWindow
sevOpenSchematic
sevOpenXmlFile
sevOpenXterm
sevOptimizationTool
sevPCMTool
sevPKGTool
sevParametricTool
sevParasiticsDisplayed
sevParasiticsNotDisplayed
sevPlotAllOutputs
sevPlotSignals
sevPrintResults
sevQuit
sevReadTable
sevReadValue
sevRegisterPcellsForAnnotation
sevRemovePlotWindow
sevReset
sevRetrieveFromEffectiveCDF
sevReturnVariablesWithEmptyValues
sevRun
sevRunEngine
sevSaveOceanScript
sevSaveOptions
sevSaveResults
sevSaveState
sevSelectResults
sevSession
sevSetConnectModules
sevSetEngineOptions
sevSetMTSMode
sevSetMainWindowPulldownMenus
sevSetMenuItemLists
sevSetPropertyForSelectedOuts
sevSetSchematicPulldownMenus
sevSetSimDataDir
sevSetSolver
sevSetTopSaveDir
sevSetTypeInWindowPulldownMenus
sevSetupSimulationFiles
sevSetupStimuli
sevSimulator
sevStartSession
sevStopEngine
sevTopSaveDir
sevViewCompilerLog
sevViewElabLog
sevViewNcVerilogLog
sevViewNetlisterLog
sevViewSimLog
sevViewSimulatorOutput
sevWhatsNew
sevWriteTable
sevWriteValue
shadow
shadowImport
sharedInitialize
simAddProbeCapByName
simAddProbeCapByScreen
simAddProbeCapForBusBit
simCheckExist
simCheckHeader
simCheckVariables
simCheckViewConfig
simCleanRun
simDateStamp
simDeRegPostNetlistTrigger
simDeRegPreNetlistTrigger
simDeleteRunDirFile
simDesignVarCdsNameExtName
simDesignVarExtNameCdsName
simDrain
simEditFileWithName
simExecute
simFindFile
simFlattenWithArgs
simGetLoginName
simGetTermList
simIfNoProcedure
simIlSleep
simInWithArgs
simInitControl
simInitEnv
simInitEnvWithArgs
simInitRaw
simInitRunDir
simInitSimulator
simInstCdsNameExtName
simInstExtNameCdsName
simJobMonitor
simLoadNetlisterFiles
simLoadSimulatorFiles
simNetCdsNameExtName
simNetExtNameCdsName
simNetlistWithArgs
simNoNetlist
simOutWithArgs
simPostNameConvert
simPostNetlistTriggerList
simPreNameConvert
simPreNetlistTriggerList
simPrintEnvironment
simPrintError
simPrintErrorLine
simPrintMessage
simPrintTermList
simReadNetCapFile
simRegPostNetlistTrigger
simRegPreNetlistTrigger
simRep
simRunDirInfile
simRunDirLoad
simRunDirOutfile
simRunNetAndSim
simRunNetAndSimWithArgs
simRunNetAndSimWithCmd
simSetDef
simSetDefWithNoWarn
simStringsToList
simSubProbeCapByName
simSubProbeCapByScreen
simVertToHoriz
simViewFileWithArgs
simWaveOpen
simin
simout
simplifyFilename
simplifyFilenameUnique
simulator
sin
sinh
skDisableMessage
skDisableMessageBlock
skEnableMessageBlock
skIgnoreMessage
skTabulate
skTabulateSKILL
skUnignoreMessage
skewness
skillDebugger
skillDevStatus
sklint
slaAddCornerModelFile
slaAddCornerVariable
slaAddDocument
slaAddSweepVariable
slaAddToParametricSet
slaAreParametricSetsEnabled
slaCreateCornerSetup
slaCreateSimulationSetup
slaCreateSweepSetup
slaCreateVerificationSpace
slaExportSetup
slaGetAllDocuments
slaGetCornerModels
slaGetCornerSetupCorners
slaGetCornerSetups
slaGetCornerVars
slaGetDocumentAbsolutePath
slaGetParametricSets
slaGetSimulationSetupRunOptionValue
slaGetSimulationSetupRunOptions
slaGetSimulationSetups
slaGetSweepSetupVars
slaGetSweepSetups
slaGetVerificationSpaces
slaGroupAsParametricSet
slaImportCorners
slaImportSetup
slaImportSweeps
slaOpenOrCreateView
slaRemoveCorner
slaRemoveCornerModel
slaRemoveCornerSetup
slaRemoveCornerVariable
slaRemoveFromParametricSet
slaRemoveSimulationSetup
slaRemoveSweepSetup
slaRemoveSweepVariable
slaRemoveVerificationSpace
slaSaveAndCloseView
slaSetParametricSetsEnabled
slaSetSimulationSetupRunOptionValue
slaUngroupParametricSet
slewRate
slotBoundp
slotUnbound
slotValue
sltSetContextSpecificationCells
sltShapeConsecutiveSlotting
smithType
soiEnableDrcDfm
solver
sort
sortcar
sourceStability
sp
spcinGuiDisplay
spdCalcOdSpacingWithPoly
spdGetAbutName
spdGetAbutStrategy
spdGetSymDeviceInfo
spdGetUserAbutProc
spdGetUserFlowProc
spdPerformAbutment
spdRegUserAbutProc
spdRegUserFlowProc
spdUnregUserAbutProc
spdUnregUserFlowProc
spectralPower
spectrumMeasurement
spm
sprintf
sprobeData
sqrt
srandom
ssb
sstatus
stacktrace
startCdsenvEditor
startFinder
status
stddev
step
stepend
stepout
stimulusFile
store
strcat
strcmp
stringToFunction
stringToSymbol
stringToTime
stringp
strlen
strncat
strncmp
strpbrk
sub1
subclassesOf
subclassp
subst
substring
sumOPParamV2
superclassesOf
suspendJob
swapSweep
sweepNames
sweepValues
sweepVarValues
swindow
swindowp
sxtd
symbolToString
symbolp
symeval
symstrp
system
tableToList
tablep
tailp
tan
tangent
tanh
tcDisplayAttachTechForm
tcDisplayCompTechForm
tcDisplayDiscardTechForm
tcDisplayDumpTechForm
tcDisplayLoadTechForm
tcDisplayNewTechForm
tcDisplaySaveTechForm
tcDisplayTechGraphForm
tcDumpTechFile
tcLoadTechFile
tcNewLibDisplayRefTechForm
tcQcInstallDevices
tcRegPostAttachTrigger
tcRegPostDumpTrigger
tcRegPostLoadTrigger
tcRegPostSetRefTrigger
tcRegPreDumpTrigger
tcRegPreLoadTrigger
tcUnregPostAttachTrigger
tcUnregPostDumpTrigger
tcUnregPostLoadTrigger
tcUnregPostSetRefTrigger
tcUnregPreDumpTrigger
tcUnregPreLoadTrigger
tconc
teDiscardEdits
teGetCursorPosition
teIsModified
teRegPostExtractTrigger
teRegPreExtractTrigger
teSave
teSaveWithDerivedData
teSetCursor
teSetEditMode
teUnRegPostExtractTrigger
teUnRegPreExtractTrigger
techBindTechFile
techCloseTechFile
techCopyTechFile
techCreateArraySiteDef
techCreateCustomViaDef
techCreateCustomViaDefByName
techCreateCustomViaVariant
techCreateDerivedLayer
techCreateElectricalRuleTable
techCreateFingerDef
techCreateGenViaDef
techCreateGenViaVariant
techCreateLP
techCreateLayer
techCreatePurpose
techCreatePurposeDef
techCreateRelatedSnapPatterns
techCreateScalarSiteDef
techCreateSnapPatternDef
techCreateSpacingRuleTable
techCreateStdViaDef
techCreateStdViaVariant
techCreateViaSpec
techCreateWaveguideDef
techCreateWidthSpacingPattern
techCreateWidthSpacingPatternGroup
techCreateWidthSpacingPatternWithColor
techCreateWidthSpacingSnapPatternDef
techCreateWireProfile
techCreateWireProfileGroup
techDeleteDeviceClass
techDeleteFingerDef
techDeleteLP
techDeleteLayer
techDeletePurpose
techDeletePurposeDef
techDeleteRelatedSnapPatterns
techDeleteSiteDef
techDeleteSnapPatternDef
techDeleteTechFile
techDeleteTechLibName
techDeleteTwoLayerProp
techDeleteViaDef
techDeleteViaSpec
techDeleteWaveguideDef
techDeleteWidthSpacingPattern
techDeleteWidthSpacingPatternGroup
techDeleteWidthSpacingSnapPatternDef
techDeleteWireProfile
techDeleteWireProfileGroup
techExportWireProfileSet
techFindFingerDef
techFindLayer
techFindPurposeDef
techFindRelatedSnapPatterns
techFindSiteDefByName
techFindSnapPatternDefByLP
techFindSnapPatternDefByName
techFindViaDefByName
techFindViaSpec
techFindViaVariantByName
techFindWaveguideDefByLP
techFindWidthSpacingPattern
techFindWidthSpacingPatternGroup
techFindWidthSpacingSnapPatternDefByName
techFindWireProfile
techFindWireProfileGroup
techGetCellViewSiteDefs
techGetCurrentDensityRuleTable
techGetCurrentDensityRuleTables
techGetCurrentDensityRules
techGetDBUPerUU
techGetDefaultTechName
techGetDerivedLayer
techGetDeviceCParam
techGetDeviceCellView
techGetDeviceClass
techGetDeviceClassProp
techGetDeviceClassViewList
techGetDeviceFParam
techGetDeviceInClass
techGetDeviceProp
techGetDeviceTechFile
techGetElectricalRuleTable
techGetElectricalRuleTableEntry
techGetElectricalRuleTables
techGetElectricalRules
techGetEquivLayers
techGetExtractCAP
techGetExtractDIODE
techGetExtractDevices
techGetExtractMOS
techGetExtractRES
techGetFabricType
techGetInstDeviceClass
techGetIntegrationColorModel
techGetLP
techGetLPAttr
techGetLPPacketName
techGetLPPriorityInContext
techGetLPProp
techGetLPsByPriority
techGetLabelLayers
techGetLayerAbbrev
techGetLayerAnalysisAttribute
techGetLayerAnalysisAttributeLock
techGetLayerFunction
techGetLayerFunctions
techGetLayerMaskNumber
techGetLayerMfgResolution
techGetLayerMfgResolutions
techGetLayerName
techGetLayerNum
techGetLayerNumColorMasks
techGetLayerProp
techGetLayerRoutingDirections
techGetLayerRoutingGrid
techGetLayerRoutingGrids
techGetLeLswLayers
techGetLxExtractLayers
techGetLxNoOverlapLayers
techGetMPPTemplateByName
techGetMPPTemplateNames
techGetMfgGridResolution
techGetOpenTechFiles
techGetOrderLPPriorityInContext
techGetOrderLeLsw
techGetOrderedElectricalRules
techGetOrderedSpacingRules
techGetOuterViaLayers
techGetParam
techGetParams
techGetPermission
techGetPermissions
techGetPrGenViaParams
techGetPrGenViaRules
techGetPrMastersliceLayers
techGetPrNonDefaultParams
techGetPrNonDefaultRules
techGetPrRoutingDirection
techGetPrRoutingLayers
techGetPrRoutingOffset
techGetPrRoutingPitch
techGetPrStackVias
techGetPrViaParams
techGetPrViaRules
techGetPrViaType
techGetPrViaTypes
techGetProcessNode
techGetPurposeAbbrev
techGetPurposeName
techGetPurposeNum
techGetRelatedSnapPatterns
techGetSpacingRuleTable
techGetSpacingRuleTableEntry
techGetSpacingRuleTables
techGetSpacingRules
techGetStampLabelLayers
techGetStdViaDefCutColoring
techGetTechCutColoring
techGetTechFile
techGetTechFileDdId
techGetTechFileName
techGetTechLibName
techGetTimeStamp
techGetTrimLayer
techGetTrimLayerPairs
techGetTrimLayers
techGetTrimmedLayers
techGetTwoLayerProp
techGetUserUnit
techGetViaLayers
techGetViaSpecTableEntries
techGetViaSpecTableEntriesByName
techGetViaSpecTableEntry
techGetViaStackLimit
techGetViaStackLimits
techGetViewTypeUnits
techGetWidthSpacingPatternAllowedRepeatMode
techGetWidthSpacingPatternDefaultRepeatMode
techGetWidthSpacingPatternGroups
techGetWidthSpacingPatterns
techGetWidthSpacingSnapPatternDefsByLP
techHasLayerAnalysisAttribute
techHasWaveguideDefMinBendRadius
techImportWireProfileSet
techIsDBUPerUUSet
techIsDevice
techIsLPValidBase
techIsLeLswLayer
techIsLxExtractLayer
techIsLxNoOverlapLayer
techIsMfgGridResolutionSet
techIsPrMastersliceLayer
techIsPrRoutingLayer
techIsPrStackVia
techIsPrViaDevice
techIsReadPermission
techIsStdViaDefCutColoringSet
techIsUserUnitSet
techIsViaLayer
techMakeVirtuosoIccInfo
techManagerOpenDisplayToolBox
techManagerOpenTechToolBox
techOpenDefaultTechFile
techOpenTechFile
techOrderLPPriorityInContext
techOrderLeLsw
techPurgeTechFile
techRefreshTechFile
techRegisterUserDevice
techReopenTechFile
techSaveTechFile
techSetDBUPerUU
techSetDeviceClassProp
techSetDeviceProp
techSetElectricalRule
techSetElectricalRuleTableEntry
techSetEquivLayer
techSetEquivLayers
techSetEvaluate
techSetExtractCAP
techSetExtractDIODE
techSetExtractMOS
techSetExtractRES
techSetFabricType
techSetIntegrationColorModel
techSetLPAttr
techSetLPPacketName
techSetLPPriorityInContext
techSetLabelLayer
techSetLabelLayers
techSetLayerAbbrev
techSetLayerAnalysisAttribute
techSetLayerAnalysisAttributeLock
techSetLayerFunction
techSetLayerFunctions
techSetLayerMaskNumber
techSetLayerMfgResolution
techSetLayerMfgResolutions
techSetLayerName
techSetLayerNumColorMasks
techSetLayerProp
techSetLayerRoutingGrid
techSetLayerRoutingGrids
techSetLeLswLayer
techSetLeLswLayers
techSetLxExtractLayer
techSetLxExtractLayers
techSetLxNoOverlapLayer
techSetLxNoOverlapLayers
techSetMPPTemplate
techSetMfgGridResolution
techSetOrderedElectricalRule
techSetOrderedSpacingRule
techSetParam
techSetPrGenViaRule
techSetPrMastersliceLayer
techSetPrMastersliceLayers
techSetPrNonDefaultRule
techSetPrRoutingLayer
techSetPrRoutingLayers
techSetPrRoutingOffset
techSetPrRoutingPitch
techSetPrStackVia
techSetPrStackVias
techSetPrViaRule
techSetPrViaType
techSetPrViaTypes
techSetPrecision
techSetReadPermission
techSetReadWritePermission
techSetSpacingRule
techSetSpacingRuleTableEntry
techSetStampLabelLayer
techSetStampLabelLayers
techSetStdViaDefCutColoring
techSetTechCutColoring
techSetTechLibName
techSetTimeStamp
techSetTwoLayerProp
techSetUserUnit
techSetViaDefResistancePerCut
techSetViaSpecTableEntry
techSetViaStackLimit
techSetViaStackLimits
techSetWaveguideDefMinBendRadius
techSetWidthSpacingPatternRepeatMode
techSupportsLayerAnalysisAttributes
techTruncateTechFile
techUnattachTechFile
techUnregisterUserDevice
techVerifyTechFileId
tedSaveCSV
tedSaveXML
temp
textFontMap
tfEditTechfile
thd
thd_fd
theEnvironment
throw
timeToString
timeToTm
times
tmToTime
topBaseLine
topEdge
topLine
toplevel
totalNoise
tpaDeselect
tpaSelect
tpaSelectWSSPDef
tpaSetActivePattern
tpaSetAllDefsVisible
tpaSetDefVisible
tpaSetFilterByName
tpaSetFilterByNumber
tpaSetRegionActivePattern
tpaSetRegionDefVisible
tpaSetRegionWireType
tpaSetWireType
tpaToggleDef
tpaToggleLayer
tpaToggleRegionLayer
tpoIsLayoutEXL
tpoIsLayoutXL
tracef
tracelevlimit
tracelevunlimit
tracep
tracev
tran
transCdlOutDisplay
treeSaveHierarchy
treeSaveScreen
triggeredDelay
truename
truncate
tsg
ttrGetCurrentScope
ttrGetScopes
ttrGetTime
ttrStartTracking
ttrStopTracking
txAppendObjectToFigSet
txClearFigSet
txCloneFigSet
txConcatFigSet
txCopyFigSet
txCreateFigSet
txDeleteFigSet
txFindFigSet
txGetCellViewFigSets
txGetFigSetBBox
txGetFigSetData
txIsFigSet
txMakeFigSet
txMoveFigSet
txPrependObjectToFigSet
txRemoveFigSetData
txRemoveObjectFromFigSet
unalias
unbindVar
unbreakpt
unbreakptMethod
uncount
undrawEnterFun
unimportSymbol
uninstallDebugger
unityGainFreq
unless
unprofile
unsetShellEnvVar
untrace
untracep
untracev
unuseNamespace
unwatch
unwindProtect
updateDependent
updateInstanceForDifferentClass
updateInstanceForRedefinedClass
updateReturnPopupMenuItem
upperCase
upperRight
useNamespace
userAppTrigger
userMenuTrigger
userPostInstallTriggers
v
value
valueAt
vcdFile
vcdInfoFile
vcpfeCreateRows
vcpfePlaceBoundaryCells
vcpfePlaceConstraintGroup
vcpfePlaceFillers
vcpfePlaceTapCells
vcpfeRegisterPostPlacementProc
vcpfeRunCustomDigitalPlacer
vdb
vdrCheckVoltageLabels
vdrCreateUserdvConstraintsFromFile
vdrCreateVSyncConstraintsFromFile
vdrCreateVoltageLabel
vdrCreateVoltageLabelEx
vdrCreateVoltageLabelOnNets
vdrCreateVoltageMarkers
vdrCreateVoltageMarkersOnNets
vdrDebuggerGUI
vdrDeleteGUI
vdrDeleteLabels
vdrDisplaySchematicGUI
vdrGenerateLabelsGUI
vdrGenerateUserdvShapes
vdrGenerateVSyncShapes
vdrGetValidLayers
vdrRunSanityChecker
vdrRunUserdvSanityChecker
vdrRunVSyncSanityChecker
vdrSanityCheckerGUI
vdrSetNetVoltageRange
vdrSetValidLayers
vdrTransferVSyncConstraints
vdrVsyncVisualizerGUI
vecFile
vector
vectorToList
vectorp
verifAddCustomOutput
verifAddDocument
verifAddImage
verifAddImp
verifAddImpSet
verifAddImpToImpSet
verifAddReq
verifAreSnapshotsEnabled
verifCheck
verifCheckImp
verifCloseSession
verifCompareImplementationsFromSnapshot
verifCompareImportedFiles
verifCopyAndUpdateResultsFromUserDefinedDirectory
verifCreateBatchScript
verifCreateRandomId
verifCreateSnapshot
verifCreateSnapshotConfiguration
verifCreateVPlan
verifCreateVsifScript
verifDeleteReqSignoff
verifDeleteSnapshot
verifDeleteSnapshotConfiguration
verifDisableDebug
verifDocumentExists
verifDownloadFromVManager
verifEnableDebug
verifEvaluateResults
verifExportCoverageDataForImp
verifExportCoverageDataForReq
verifExportJson
verifExportMapping
verifExportReqsToFile
verifExportSnapshotsToExcel
verifGetAllSessions
verifGetCallbacks
verifGetCellViewSession
verifGetCustomFieldNames
verifGetCustomFieldValue
verifGetDebug
verifGetDocuments
verifGetImages
verifGetImpData
verifGetImpEstRunTime
verifGetImpMapping
verifGetImpPriority
verifGetImpSetPreRunScript
verifGetImpSets
verifGetImpTestOutputs
verifGetImpTests
verifGetImportedFiles
verifGetImps
verifGetImpsInImpSet
verifGetMappableType
verifGetOptionVal
verifGetOptions
verifGetReferenceSnapshot
verifGetReferencedCellViews
verifGetReqCustomFieldNames
verifGetReqCustomFieldValue
verifGetReqMapping
verifGetReqParent
verifGetReqProp
verifGetReqProps
verifGetReqSignoff
verifGetReqStatus
verifGetReqs
verifGetResultDataForImp
verifGetResultDataForReq
verifGetSessionCellView
verifGetSetupLibrary
verifGetSnapshot
verifGetSnapshotAbsoluteTolerance
verifGetSnapshotComment
verifGetSnapshotRelativeTolerance
verifGetSnapshots
verifGetSnapshotsData
verifGetTypicalSetup
verifGetVManager
verifGetVManagerProjects
verifGetWindow
verifImageExists
verifImpIsRun
verifImportFile
verifImportMapping
verifIsBatchRunProcess
verifIsSessionModified
verifIsSessionReadOnly
verifIsSnapshotLocked
verifIsSnapshotVisible
verifIsVManagerConnected
verifIsVManagerEnabled
verifIsValidSession
verifMapping
verifMergeImportedFiles
verifMoveImp
verifMoveReq
verifOpenCellView
verifOverwriteSpec
verifPostResultsToVManager
verifPublishHTML
verifRegisterCallback
verifReloadAllRes
verifRemoveCallback
verifRemoveDocument
verifRemoveImage
verifRemoveImp
verifRemoveImpFromImpSet
verifRemoveImpSet
verifRemoveReq
verifRemoveVManager
verifRenameSnapshot
verifRestart
verifRestoreFromSnapshot
verifRun
verifSaveSession
verifSaveSessionAs
verifSetCustomFieldValue
verifSetImpData
verifSetImpEstRunTime
verifSetImpPriority
verifSetImpRun
verifSetImpSetName
verifSetImpSetPreRunScript
verifSetOptionVal
verifSetReferenceSnapshot
verifSetReqCellviewHolder
verifSetReqCustomFieldValue
verifSetReqId
verifSetReqProp
verifSetReqTitle
verifSetReqType
verifSetSetupLibrary
verifSetSnapshotAbsoluteTolerance
verifSetSnapshotComment
verifSetSnapshotConfiguration
verifSetSnapshotLocked
verifSetSnapshotRelativeTolerance
verifSetSnapshotVisible
verifSetSnapshotsEnabled
verifSetVManager
verifSignOffReq
verifStop
verifUpdate
verifUpdateImpEstRunTime
verifUploadToVManager
verifVPlanExists
vfoAbut
vfoAdvGRUpdateCDF
vfoAllocateProtocolObj
vfoAllocateShapeData
vfoChopInstance
vfoConvertToPolygon
vfoCreateAutoFGR
vfoCreateObstruction
vfoCreateObstructions
vfoCreateShapeData
vfoDeleteObstruction
vfoDoSnapToSnapPattern
vfoDrawFluidShape
vfoGRCleanVersionCache
vfoGRCompareParams
vfoGRCreateDeviceClass
vfoGRDisableVersionCache
vfoGREnableVersionCache
vfoGRGeometry
vfoGRGetCommonQPtr
vfoGRGetCreateFormFieldProp
vfoGRGetCreateFormIdentifier
vfoGRGetCreateFormPointer
vfoGRGetExtraArgument
vfoGRGetExtraArgumentName
vfoGRGetQueuePointer
vfoGRMaximizeShapes
vfoGRNewCreateForm
vfoGRRegCreateFormUpdateCallback
vfoGRSetCreateFormAllFieldsInvisible
vfoGRSetCreateFormFieldProp
vfoGRSetExtraArgument
vfoGRSmoothen
vfoGRUpdateCreateFormSize
vfoGRUpdateTunnelLPPs
vfoGRUpdateTunnelOptions
vfoGRUpdateVersionCache
vfoGetDeviceClassParam
vfoGetDeviceFormalParam
vfoGetFileListWithLoadSequence
vfoGetImplementationClassName
vfoGetInstWithMissingCache
vfoGetParam
vfoGetProtocolClassName
vfoGetVersion
vfoGrCreateCDF
vfoInstallFluidDeviceFiles
vfoIsCommandInDragMode
vfoIsGuardRing
vfoMergeInstances
vfoPostChopCBHandler
vfoPostReshapeCBHandler
vfoPostSplitCBHandler
vfoPostStretchCBHandler
vfoReInstallAllFluidGuardRingDevices
vfoReInstallGuardRingDevice
vfoRotateInstance
vfoSetParam
vfoSetParams
vfoSetProtocolClassName
vfoSfDraw
vfoSfFinalize
vfoSfInitialize
vfoSfOuterEdgeCornerContRemoval
vfoSmoothen
vfoSupportsAbut?
vfoSupportsChop?
vfoSupportsConvertToPolygon?
vfoSupportsCreateObstruction?
vfoSupportsCreateObstructions?
vfoSupportsDeleteObstruction?
vfoSupportsMerge?
vfoSupportsRotation
vfoSupportsUpdateModelShape?
vfoSupportsVersionCache
vfoTransformFluidShape
vfoTunnelHigherMetalLayers
vfoUpdateModelShape
vfpAlignPins
vfpAutoPin
vfpCPHGenPhysicalHier
vfpCPHGenPhysicalHierNoPropFile
vfpCPHLoadFloorplanFile
vfpCreateBoundaryPinsForSelectedShapes
vfpHiPushPreRoutesDown
vfpLoadPhysicalView
vfpPinConnectivitySetting
vfpPinSnapToEdge
vfpPtAddPinResizeEstimator
vfpPtGetPinResizeEstimators
vfpPtLoadPinResizeFile
vfpPtRemovePinResizeEstimator
vfpPtRunPinResizeEstimator
vfpPushPreRoutesDown
vfpReportIOPadLocation
vfpSbDefineObstruction
vfpSbDeleteObstruction
vfpSbEditIOPin
vfpSbEditSoftBlockType
vfpSbSetPolygonalBoundary
vfpSbSetRectangularBoundary
vfreq
vfreqterm
vh
vhdlHiImport
vhdlHiInvokeToolBox
vhdlImport
vhdlPinListToVHDL
vhdlRegisterSimulator
vhdlToPinList
vhmsCompilationFailure
vhmsDefaultEdit
vhmsGetCellParameters
vhmsPinListToVHDLAMS
vhmsSaveFile
vhmsSymbolToPinListGen
vhmsToPinList
vhmsUpdateCellCDFParams
vhterm
viaFindTransitions
viaGenerateViasAtPoint
viaGenerateViasFromShapes
viaGenerateViasInArea
viaGetViaOptions
viaLoadViaVariants
viaRecomputeVias
viaRecomputeViasAtPoint
viaRecomputeViasInArea
viaRegisterCreateViaInitCallback
viaRegisterPostViaEngineCallback
viaRegisterPostViaServerCallback
viaRegisterPreViaEngineCallback
viaSaveViaVariants
viaSetDefaultCutClasses
viaSetDefaultValidViaDefs
viaUnregisterCreateViaInitCallback
viaUnregisterPostViaEngineCallback
viaUnregisterPostViaServerCallback
viaUnregisterPreViaEngineCallback
vicOpenVlogCallBack
view
vim
vivaInitBindkeys
vivaIsVivaExecutable
vlVicCrossSelectionForm
vlVicPSForm
vlogifCrossSelectionCB
vm
vmsUpdateCellViews
vmtCompareSipToOa
vmtLibImport
vmtValidateUnifiedLibrary
vmtcsvCreateComponentCellViewsFromCsv
vmtcsvInstallCsvFile
vosHiDisplayNetlist
vosLaunchIrunSimulation
vp
vpaOptimizePins
vpmDefinePowerSwitchInstance
vpmExportDotLib
vpmExportPowerIntent
vpmExportPowerIntentSetup
vpmExportPowerModel
vpmExtractPowerIntent
vpmGenerateSigInfo
vpmImportPowerIntent
vpmImportPowerIntentSetup
vpmLoadInDesignViolations
vpmRemoveImportedPowerIntent
vpmRemovePowerSwitchInstance
vpmRunInDesignChecks
vpmSetViolationBrowserOptions
vr
vreDeletePhysicalCells
vreDeletePowerRouting
vreDeleteRowRegions
vreDeleteSignalRouting
vreFinishRouting
vreGenerateWSPs
vreGetCellView
vreGetHandle
vreGetOption
vreGetOptions
vreGetRouter
vreGetRoutingStyle
vreIsOption
vreRaiseConstraintManager
vreRaisePreRoutingBrowser
vreRaiseResultsBrowser
vreRemoveJogs
vreRemoveNotches
vreRunAssistedRouter
vreRunChecker
vreRunGeneration
vreRunP2TRouter
vreRunPlacer
vreRunSignalRouter
vreSetOption
vreSetOptions
vreSetRouter
vreSetRoutingStatus
vreSetRoutingStyle
vreShowCheckerLog
vreShowPlacerLog
vreShowRowGenLog
vreShowSignalRouterLog
vreStopPlacer
vreStopRowRegionCreation
vreStopSignalRouter
vreStopWSPGeneration
vrfCheckTILPVersion
vrfComplianceAudit
vrfExportLayoutSkill
vrfExportPackage
vrfHiUpdate
vrfLowerPriority
vrfRaisePriority
vrfSipGet
vrfSipSet
vrfTLineAbut
vrfUpdateTILPVersion
vrtCheckDesign
vrtCreateIDLayer
vrtDeleteNets
vrtPowerRoute
vrtRouteAssisted
vrtRouteDesign
vrtStrandRoute
vsaCreateMarker
vsaDescendView
vsaLoadEM
vsaLoadIR
vsaLoadNets
vsaLoadSecondaryLayers
vsaOpenLayout
vsaOpenSchematic
vsaSelectFailedNets
vsaSetDfiiLayerMapFileName
vsaSetEMIRConfig
vsaSetEMLayerMapFileName
vsaSetEMOnlyICTFile
vsaSetEMPlot
vsaSetEMResultsFile
vsaSetEMTechFileName
vsaSetEMTypes
vsaSetFinerDisplayOff
vsaSetIRPlot
vsaSetIRResultsFile
vsaSetIRThreshold
vsaSetInputType
vsaSetLRPShortedLayers
vsaSetLayersToMergeDuringResultsLoading
vsaSetParallelLoading
vsaSetQRCData
vsaShowAllResistors
vsrDeletePreset
vsrLoadPreset
vsrSavePreset
vswr
vtime
vtimeterm
vvDisplayBrowser
vvDisplayCalculator
vvGetGraphBackground
vvSetGraphBackground
vxfiLoadEMIRResults
vxfiLoadNets
vxfiOpenLayout
vxfiSaveNetSummaryInfoToCSV
vxfiSessionConnect
vxfiSessionRegisterCreationCallback
vxfiSetLVSQueryOutputDirectory
vxfiSetLVSRunName
wait
warn
watch
waveVsWave
weAddCustomTransitionMenuItem
weCWHoldWidth
weCycleCutColorVia
weCyclePatternGravityLayerTransitionType
weGatherBusWires
weGetAdjustedWidthForTracks
weGetCustomTransitionMenuItems
weGetPathSegWidth
weHiCopyRoute
weHiCycleViaDefDown
weHiCycleViaDefUp
weHiEditBus
weHiInteractiveRouting
weHiWireTo45
weRemoveCustomTransitionMenuItem
weScaleMagnifierOrDecreaseWidth
weScaleMagnifierOrIncreaseWidth
weScrollOrCycleDownWireViaAlignment
weScrollOrCycleUpWireViaAlignment
weSetPathSegWidth
when
where
whereIs
which
while
window
windowp
write
writeTable
wspCheckActive
wspCreateWSP
wspCreateWSPByAttr
wspCreateWSPGroup
wspCreateWSSPDef
wspCreateWSSPDefByAttr
wspDeleteCellViewAllWSPData
wspDeleteMetalFill
wspDumpToFile
wspGetLineEndGrids
wspGetWSSPDefLP
wspRegionFindByLayer
wspRegionFindByWSSPDef
wspRegionGetActivePattern
wspRegionGetAllowedPatternGroups
wspRegionGetAllowedPatterns
wspRegionGetWSSPDef
wspSPDefFind
wspSetWSSPDefRegionPurpose
wspWSPFindByName
wspWSPGetFlatAttr
wspWSPGroupFindByName
wspWSSPDefAddToAllowedPatternGroups
wspWSSPDefAddToAllowedPatterns
wspWSSPDefAddToEnabled
wspWSSPDefClearEnabledOverrides
wspWSSPDefFind
wspWSSPDefFindByName
wspWSSPDefGetActivePattern
wspWSSPDefGetAllowedPatternGroups
wspWSSPDefGetAllowedPatterns
wspWSSPDefGetAttr
wspWSSPDefGetEnabledOverrides
wspWSSPDefRemoveFromAllowedPatternGroups
wspWSSPDefRemoveFromAllowedPatterns
wspWSSPDefRemoveFromEnabled
wspWSSPDefRename
wspWSSPDefSetActivePattern
wspWSSPDefSetAllowedPatternGroups
wspWSSPDefSetAllowedPatterns
wspWSSPDefSetEnabledOverrides
wtypep
xCoord
xLimit
xcons
xdifference
xdvReplaceInstWithVias
xfgrAddOption
xfgrConfigureOptionsCB
xfgrDisableOption
xfgrEnableOption
xfgrGetAvailableValues
xfgrGetOptionValue
xfgrHideAllGroups
xfgrHideAllOptions
xfgrHideGroup
xfgrHideOption
xfgrInitializeOptionsCB
xfgrOptionValueChangeCB
xfgrPostCreateCB
xfgrPreCreateCB
xfgrSetAvailableValues
xfgrSetOptionValue
xfgrSetTableCellValue
xfgrShowAllGroups
xfgrShowGroup
xfgrShowOption
xmax
xmin
xoasInDoTranslate
xoasInGetField
xoasInOnCancel
xoasInOnCancelCB
xoasInOnCompletion
xoasInOnCompletionCB
xoasInOnTranslate
xoasInOnTranslateCB
xoasInSetField
xoasOutDoTranslate
xoasOutGetField
xoasOutOnCancel
xoasOutOnCancelCB
xoasOutOnCompletion
xoasOutOnCompletionCB
xoasOutOnTranslate
xoasOutOnTranslateCB
xoasOutSetField
xor
xpcDumpCache
xpcEnableExpressPcell
xplus
xquotient
xstGetField
xstInDoTranslate
xstInGetField
xstInGetVMLibs
xstInOnCancel
xstInOnCancelCB
xstInOnCompletion
xstInOnCompletionCB
xstInOnTranslate
xstInOnTranslateCB
xstInSaveVMLib
xstInSetField
xstOutDoTranslate
xstOutOnCancel
xstOutOnCancelCB
xstOutOnCompletion
xstOutOnCompletionCB
xstOutOnTranslate
xstOutOnTranslateCB
xstSetField
xtimes
xval
yCoord
yLimit
ymax
ymin
ypm
zerop
zm
zpm
zref
zxtd)
    (fprintf p "%s|%L\n" sym (isCallable sym)))
  (close p)
  (exit))
