;; Golden Case（隔离库 /tmp 下）：PDK 读取 → 器件 → CDF 参数 → 检查 → 存盘 → 回读
(let (pdklib cdf cv inst p w1 w2 chk saved)
  (printf "@@S1_pdk=%L@@" (setq pdklib (ddGetObj "tsmcN65")))
  (printf "@@S2a_cell=%L@@" (ddGetObj "tsmcN65" "nch"))
  (printf "@@S2b_cdf=%L@@" (setq cdf (cdfGetCellCDF (ddGetObj "tsmcN65" "nch"))))
  (printf "@@S2c_baseCDF=%L@@" (cdfGetBaseCellCDF pdklib))
  (printf "@@S3_lib=%L@@" (ddCreateLib "vlAudit" "./vlAudit"))
  (setq cv (dbOpenCellViewByType "vlAudit" "gcase" "schematic" "schematic" "w"))
  (printf "@@S4_cv=%L@@" cv)
  (setq inst (dbCreateInstByMasterName cv "tsmcN65" "nch" "symbol" "M0" 0:0 "R0"))
  (if (null inst)
      (setq inst (dbCreateInstByMasterName cv "analogLib" "nmos4" "symbol" "M0" 0:0 "R0")))
  (printf "@@S5_inst=%L@@" inst)
  (printf "@@S6_setw=%L@@" (dbReplaceProp inst "w" "string" "1u"))
  (printf "@@S7_setl=%L@@" (dbReplaceProp inst "l" "string" "60n"))
  (printf "@@S8_readw=%L@@" (dbGetPropByName inst "w"))
  (printf "@@S9_readl=%L@@" (dbGetPropByName inst "l"))
  (printf "@@S10_check=%L@@" (setq chk (schCheck cv)))
  (printf "@@S11_save=%L@@" (setq saved (dbSave cv)))
  (dbClose cv)
  (setq cv (dbOpenCellViewByType "vlAudit" "gcase" "schematic" "schematic" "r"))
  (printf "@@S12_reopen_insts=%L@@" length(cv~>instances))
  (printf "@@S13_reopen_nets=%L@@" length(cv~>nets))
  (printf "@@S14_reopen_prop=%L@@" (dbGetPropByName (car cv~>instances) "w"))
  (dbClose cv)
  ;; 对抗验证（全部在沙箱库/无副作用）
  (printf "@@A1_badtype=%L@@" (errset (dbCreateRect cv (list "text" "drawing") 123)))
  (printf "@@A2_unloaded=%L@@" (if (getd 'leHiCreateRect) "loaded" "absent"))
  (printf "@@A3_nilobj=%L@@" (errset (dbCreateNet nil "X")))
  (printf "@@A4_dupinst=%L@@" (errset (dbOpenCellViewByType "vlAudit" "gcase" "schematic" "schematic" "a")))
  (printf "@@DONE=t@@"))
