// Design: vlV01_d500/tb
simulator lang=spectre
global 0
include "/eda/1P9M/TSMC065_1P9M/tsmcN65/../models/spectre/crn65gplus_2d5_lk_v1d0.scs" section=tt_bip
include "/eda/1P9M/TSMC065_1P9M/tsmcN65/../models/spectre/crn65gplus_2d5_lk_v1d0.scs" section=tt_dio
include "/eda/1P9M/TSMC065_1P9M/tsmcN65/../models/spectre/crn65gplus_2d5_lk_v1d0.scs" section=tt_dio_33
include "/eda/1P9M/TSMC065_1P9M/tsmcN65/../models/spectre/crn65gplus_2d5_lk_v1d0.scs" section=tt_mim
include "/eda/1P9M/TSMC065_1P9M/tsmcN65/../models/spectre/crn65gplus_2d5_lk_v1d0.scs" section=tt_dio_dnw
include "/eda/1P9M/TSMC065_1P9M/tsmcN65/../models/spectre/crn65gplus_2d5_lk_v1d0.scs" section=tt_dio_18
include "/eda/1P9M/TSMC065_1P9M/tsmcN65/../models/spectre/crn65gplus_2d5_lk_v1d0.scs" section=tt_bip_npn
include "/eda/1P9M/TSMC065_1P9M/tsmcN65/../models/spectre/crn65gplus_2d5_lk_v1d0.scs" section=tt_33
include "/eda/1P9M/TSMC065_1P9M/tsmcN65/../models/spectre/crn65gplus_2d5_lk_v1d0.scs" section=tt_rfrtmom
include "/eda/1P9M/TSMC065_1P9M/tsmcN65/../models/spectre/crn65gplus_2d5_lk_v1d0.scs" section=tt_mos_cap_25
include "/eda/1P9M/TSMC065_1P9M/tsmcN65/../models/spectre/crn65gplus_2d5_lk_v1d0.scs" section=tt_18
include "/eda/1P9M/TSMC065_1P9M/tsmcN65/../models/spectre/crn65gplus_2d5_lk_v1d0.scs" section=tt_disres
include "/eda/1P9M/TSMC065_1P9M/tsmcN65/../models/spectre/crn65gplus_2d5_lk_v1d0.scs" section=tt_res
include "/eda/1P9M/TSMC065_1P9M/tsmcN65/../models/spectre/crn65gplus_2d5_lk_v1d0.scs" section=tt_dio_na
include "/eda/1P9M/TSMC065_1P9M/tsmcN65/../models/spectre/crn65gplus_2d5_lk_v1d0.scs" section=tt_rfmos_33
include "/eda/1P9M/TSMC065_1P9M/tsmcN65/../models/spectre/crn65gplus_2d5_lk_v1d0.scs" section=tt_dio_hvt
include "/eda/1P9M/TSMC065_1P9M/tsmcN65/../models/spectre/crn65gplus_2d5_lk_v1d0.scs" section=tt_rfmvar
include "/eda/1P9M/TSMC065_1P9M/tsmcN65/../models/spectre/crn65gplus_2d5_lk_v1d0.scs" section=tt_rfmos_18
include "/eda/1P9M/TSMC065_1P9M/tsmcN65/../models/spectre/crn65gplus_2d5_lk_v1d0.scs" section=tt_na
include "/eda/1P9M/TSMC065_1P9M/tsmcN65/../models/spectre/crn65gplus_2d5_lk_v1d0.scs" section=tt_dio_na33
include "/eda/1P9M/TSMC065_1P9M/tsmcN65/../models/spectre/crn65gplus_2d5_lk_v1d0.scs" section=tt_dio_lvt
include "/eda/1P9M/TSMC065_1P9M/tsmcN65/../models/spectre/crn65gplus_2d5_lk_v1d0.scs" section=tt_rfres_sa
include "/eda/1P9M/TSMC065_1P9M/tsmcN65/../models/spectre/crn65gplus_2d5_lk_v1d0.scs" section=tt_na33
include "/eda/1P9M/TSMC065_1P9M/tsmcN65/../models/spectre/crn65gplus_2d5_lk_v1d0.scs" section=tt_dio_esd
include "/eda/1P9M/TSMC065_1P9M/tsmcN65/../models/spectre/crn65gplus_2d5_lk_v1d0.scs" section=tt_rfmim
include "/eda/1P9M/TSMC065_1P9M/tsmcN65/../models/spectre/crn65gplus_2d5_lk_v1d0.scs" section=tt_dio_25od33
include "/eda/1P9M/TSMC065_1P9M/tsmcN65/../models/spectre/crn65gplus_2d5_lk_v1d0.scs" section=tt_25od33
include "/eda/1P9M/TSMC065_1P9M/tsmcN65/../models/spectre/crn65gplus_2d5_lk_v1d0.scs" section=tt
include "/eda/1P9M/TSMC065_1P9M/tsmcN65/../models/spectre/crn65gplus_2d5_lk_v1d0.scs" section=tt_mos_cap
include "/eda/1P9M/TSMC065_1P9M/tsmcN65/../models/spectre/crn65gplus_2d5_lk_v1d0.scs" section=tt_dio_25
include "/eda/1P9M/TSMC065_1P9M/tsmcN65/../models/spectre/crn65gplus_2d5_lk_v1d0.scs" section=tt_dio_25ud18
include "/eda/1P9M/TSMC065_1P9M/tsmcN65/../models/spectre/crn65gplus_2d5_lk_v1d0.scs" section=tt_25
include "/eda/1P9M/TSMC065_1P9M/tsmcN65/../models/spectre/crn65gplus_2d5_lk_v1d0.scs" section=tt_rfmos
include "/eda/1P9M/TSMC065_1P9M/tsmcN65/../models/spectre/crn65gplus_2d5_lk_v1d0.scs" section=tt_25ud18
include "/eda/1P9M/TSMC065_1P9M/tsmcN65/../models/spectre/crn65gplus_2d5_lk_v1d0.scs" section=tt_dio_na25od33
include "/eda/1P9M/TSMC065_1P9M/tsmcN65/../models/spectre/crn65gplus_2d5_lk_v1d0.scs" section=tt_rfjvar
include "/eda/1P9M/TSMC065_1P9M/tsmcN65/../models/spectre/crn65gplus_2d5_lk_v1d0.scs" section=tt_rfmos_25
include "/eda/1P9M/TSMC065_1P9M/tsmcN65/../models/spectre/crn65gplus_2d5_lk_v1d0.scs" section=tt_rtmom
include "/eda/1P9M/TSMC065_1P9M/tsmcN65/../models/spectre/crn65gplus_2d5_lk_v1d0.scs" section=tt_na25od33
include "/eda/1P9M/TSMC065_1P9M/tsmcN65/../models/spectre/crn65gplus_2d5_lk_v1d0.scs" section=tt_dio_na25
include "/eda/1P9M/TSMC065_1P9M/tsmcN65/../models/spectre/crn65gplus_2d5_lk_v1d0.scs" section=tt_rfres_rpo
include "/eda/1P9M/TSMC065_1P9M/tsmcN65/../models/spectre/crn65gplus_2d5_lk_v1d0.scs" section=tt_hvt
include "/eda/1P9M/TSMC065_1P9M/tsmcN65/../models/spectre/crn65gplus_2d5_lk_v1d0.scs" section=tt_rfind
include "/eda/1P9M/TSMC065_1P9M/tsmcN65/../models/spectre/crn65gplus_2d5_lk_v1d0.scs" section=tt_rfmvar_25
include "/eda/1P9M/TSMC065_1P9M/tsmcN65/../models/spectre/crn65gplus_2d5_lk_v1d0.scs" section=tt_na25
include "/eda/1P9M/TSMC065_1P9M/tsmcN65/../models/spectre/crn65gplus_2d5_lk_v1d0.scs" section=tt_lvt

// vlV01_d500/tb/schematic
M0 (D G S B) nch l=60n w=500n m=1 nf=1
simulatorOptions options temp=27

VG (g_bias 0) vsource dc=0.6
Lg (g_bias G) inductor l=100
P1 (g_ac 0) port r=50 dc=0 mag=1 num=1
Cg (g_ac G) capacitor c=1e6
VD (d_bias 0) vsource dc=1.2
Ld (d_bias D) inductor l=100
P2 (d_ac 0) port r=50 dc=0 mag=0 num=2
Cd (d_ac D) capacitor c=1e6
VS (S 0) vsource dc=0
VB (B 0) vsource dc=0
op1 dc
sp1 sp start=10 stop=1e6 dec=10
simulatorOptions options temp=27 reltol=1e-4
