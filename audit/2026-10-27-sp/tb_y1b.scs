// Design: vlV01_d500/tb
simulator lang=spectre
global 0
include "/eda/1P9M/TSMC065_1P9M/tsmcN65/../models/spectre/crn65gplus_2d5_lk_v1d0.scs" section=tt_bip
include "/eda/1P9M/TSMC065_1P9M/tsmcN65/../models/spectre/crn65gplus_2d5_lk_v1d0.scs" section=tt_dio
include "/eda/1P9M/TSMC065_1P9M/tsmcN65/../models/spectre/crn65gplus_2d5_lk_v1d0.scs" section=tt_dio_33
include "/eda/1P9M/TSMC065_1P9M/tsmcN65/../models/spectre/crn65gplus_2d5_lk_v1d0.scs" section=tt_mim
include "/eda/1P9M/TSMC065_1P9M/tsmcN65/../models/spectre/crn65gplus_2d5_lk_v1d0.scs" section=tt_dio_dnw
include "/eda/1P9M/TSMC065_1P9M/tsmcN65/../models/spectre/crn65gplus_2d5_lk_v1d0.scs" section=tt_dio_18
include "/eda/1P9M/TSMC065_1P9M/tsmcN65/../models/spectre/crn65gplus_2d5_lk_v1d0.scs" section=tt_bip_npn
include "/eda/1P9M/TSMC065_1P9M/tsmcN65/../models/spectre/crn65gplus_2d5_lk_v1d0.scs" section=tt_33
include "/eda/1P9M/TSMC065_1P9M/tsmcN65/../models/spectre/crn65gplus_2d5_lk_v1d0.scs" section=tt_rfrtmom
include "/eda/1P9M/TSMC065_1P9M/tsmcN65/../models/spectre/crn65gplus_2d5_lk_v1d0.scs" section=tt_mos_cap_25
include "/eda/1P9M/TSMC065_1P9M/tsmcN65/../models/spectre/crn65gplus_2d5_lk_v1d0.scs" section=tt_18
include "/eda/1P9M/TSMC065_1P9M/tsmcN65/../models/spectre/crn65gplus_2d5_lk_v1d0.scs" section=tt_disres
include "/eda/1P9M/TSMC065_1P9M/tsmcN65/../models/spectre/crn65gplus_2d5_lk_v1d0.scs" section=tt_res
include "/eda/1P9M/TSMC065_1P9M/tsmcN65/../models/spectre/crn65gplus_2d5_lk_v1d0.scs" section=tt_dio_na
include "/eda/1P9M/TSMC065_1P9M/tsmcN65/../models/spectre/crn65gplus_2d5_lk_v1d0.scs" section=tt_rfmos_33
include "/eda/1P9M/TSMC065_1P9M/tsmcN65/../models/spectre/crn65gplus_2d5_lk_v1d0.scs" section=tt_dio_hvt
include "/eda/1P9M/TSMC065_1P9M/tsmcN65/../models/spectre/crn65gplus_2d5_lk_v1d0.scs" section=tt_rfmvar
include "/eda/1P9M/TSMC065_1P9M/tsmcN65/../models/spectre/crn65gplus_2d5_lk_v1d0.scs" section=tt_rfmos_18
include "/eda/1P9M/TSMC065_1P9M/tsmcN65/../models/spectre/crn65gplus_2d5_lk_v1d0.scs" section=tt_na
include "/eda/1P9M/TSMC065_1P9M/tsmcN65/../models/spectre/crn65gplus_2d5_lk_v1d0.scs" section=tt_dio_na33
include "/eda/1P9M/TSMC065_1P9M/tsmcN65/../models/spectre/crn65gplus_2d5_lk_v1d0.scs" section=tt_dio_lvt
include "/eda/1P9M/TSMC065_1P9M/tsmcN65/../models/spectre/crn65gplus_2d5_lk_v1d0.scs" section=tt_rfres_sa
include "/eda/1P9M/TSMC065_1P9M/tsmcN65/../models/spectre/crn65gplus_2d5_lk_v1d0.scs" section=tt_na33
include "/eda/1P9M/TSMC065_1P9M/tsmcN65/../models/spectre/crn65gplus_2d5_lk_v1d0.scs" section=tt_dio_esd
include "/eda/1P9M/TSMC065_1P9M/tsmcN65/../models/spectre/crn65gplus_2d5_lk_v1d0.scs" section=tt_rfmim
include "/eda/1P9M/TSMC065_1P9M/tsmcN65/../models/spectre/crn65gplus_2d5_lk_v1d0.scs" section=tt_dio_25od33
include "/eda/1P9M/TSMC065_1P9M/tsmcN65/../models/spectre/crn65gplus_2d5_lk_v1d0.scs" section=tt_25od33
include "/eda/1P9M/TSMC065_1P9M/tsmcN65/../models/spectre/crn65gplus_2d5_lk_v1d0.scs" section=tt
include "/eda/1P9M/TSMC065_1P9M/tsmcN65/../models/spectre/crn65gplus_2d5_lk_v1d0.scs" section=tt_mos_cap
include "/eda/1P9M/TSMC065_1P9M/tsmcN65/../models/spectre/crn65gplus_2d5_lk_v1d0.scs" section=tt_dio_25
include "/eda/1P9M/TSMC065_1P9M/tsmcN65/../models/spectre/crn65gplus_2d5_lk_v1d0.scs" section=tt_dio_25ud18
include "/eda/1P9M/TSMC065_1P9M/tsmcN65/../models/spectre/crn65gplus_2d5_lk_v1d0.scs" section=tt_25
include "/eda/1P9M/TSMC065_1P9M/tsmcN65/../models/spectre/crn65gplus_2d5_lk_v1d0.scs" section=tt_rfmos
include "/eda/1P9M/TSMC065_1P9M/tsmcN65/../models/spectre/crn65gplus_2d5_lk_v1d0.scs" section=tt_25ud18
include "/eda/1P9M/TSMC065_1P9M/tsmcN65/../models/spectre/crn65gplus_2d5_lk_v1d0.scs" section=tt_dio_na25od33
include "/eda/1P9M/TSMC065_1P9M/tsmcN65/../models/spectre/crn65gplus_2d5_lk_v1d0.scs" section=tt_rfjvar
include "/eda/1P9M/TSMC065_1P9M/tsmcN65/../models/spectre/crn65gplus_2d5_lk_v1d0.scs" section=tt_rfmos_25
include "/eda/1P9M/TSMC065_1P9M/tsmcN65/../models/spectre/crn65gplus_2d5_lk_v1d0.scs" section=tt_rtmom
include "/eda/1P9M/TSMC065_1P9M/tsmcN65/../models/spectre/crn65gplus_2d5_lk_v1d0.scs" section=tt_na25od33
include "/eda/1P9M/TSMC065_1P9M/tsmcN65/../models/spectre/crn65gplus_2d5_lk_v1d0.scs" section=tt_dio_na25
include "/eda/1P9M/TSMC065_1P9M/tsmcN65/../models/spectre/crn65gplus_2d5_lk_v1d0.scs" section=tt_rfres_rpo
include "/eda/1P9M/TSMC065_1P9M/tsmcN65/../models/spectre/crn65gplus_2d5_lk_v1d0.scs" section=tt_hvt
include "/eda/1P9M/TSMC065_1P9M/tsmcN65/../models/spectre/crn65gplus_2d5_lk_v1d0.scs" section=tt_rfind
include "/eda/1P9M/TSMC065_1P9M/tsmcN65/../models/spectre/crn65gplus_2d5_lk_v1d0.scs" section=tt_rfmvar_25
include "/eda/1P9M/TSMC065_1P9M/tsmcN65/../models/spectre/crn65gplus_2d5_lk_v1d0.scs" section=tt_na25
include "/eda/1P9M/TSMC065_1P9M/tsmcN65/../models/spectre/crn65gplus_2d5_lk_v1d0.scs" section=tt_lvt

// vlV01_d500/tb/schematic
M0 (D G S B) nch l=60n w=500n m=1 nf=1
simulatorOptions options temp=27

VD (D 0) vsource dc=1.2 mag=0 phase=0
VG (g_drv 0) vsource dc=0.6 mag=1 phase=0
AMP (g_drv G) vsource dc=0 mag=0 phase=0
VS (S 0) vsource dc=0 mag=0 phase=0
VB (B 0) vsource dc=0 mag=0 phase=0
op1 dc
ac1 ac start=10 stop=1e6 dec=10
saveOptions options save=all
simulatorOptions options temp=27 reltol=1e-4
